* Extracted by KLayout with SCL C1D LVS runset on : 10/08/2026 16:07

* cell top
* pin VSS
.SUBCKT top VSS
* cell instance $2 r180 *1 3949.64,955.7
X$2 \$18 \$1 \$I331287 \$1033 \$18 VSS DFFL11
* cell instance $4 m90 *1 4129.75,818.3
X$4 \$18 \$2 \$I331313 \$931 \$18 VSS DFFL11
* cell instance $8 r0 *1 3985.8,108.7
X$8 \$77 \$18 \$3 VSS INVR05
* cell instance $11 r0 *1 4110.86,640.9
X$11 \$18 \$4 \$I331281 \$725 \$18 VSS DFFL11
* cell instance $14 m0 *1 4069.82,68.7
X$14 \$18 \$37 \$5 VSS INVR06
* cell instance $16 r0 *1 4103.41,108.7
X$16 \$194 \$18 \$6 VSS INVR05
* cell instance $18 m0 *1 4162.21,68.7
X$18 \$18 \$39 \$7 VSS INVR04
* cell instance $22 m0 *1 4255.06,68.7
X$22 \$18 \$40 \$8 VSS INVR06
* cell instance $26 r0 *1 4454.65,108.7
X$26 \$18 \$202 \$9 VSS INVR06
* cell instance $29 r0 *1 4437.84,108.7
X$29 \$18 \$201 \$10 VSS INVR03
* cell instance $32 r180 *1 4326.46,68.7
X$32 \$18 \$41 \$42 \$10 VSS AND201
* cell instance $35 m90 *1 4625.51,640.9
X$35 \$11 \$684 \$528 \$418 \$778 \$591 \$308 \$731 \$775 \$18 VSS AND801
* cell instance $37 r180 *1 4619.54,246.1
X$37 \$11 \$18 \$325 VSS INVR05
* cell instance $40 r180 *1 4646.69,68.7
X$40 \$18 \$54 \$12 VSS INVR03
* cell instance $43 m0 *1 4645.1,246.1
X$43 \$53 \$12 \$248 \$18 VSS XNR201
* cell instance $45 m90 *1 4734.81,286.1
X$45 \$18 \$452 \$13 \$422 VSS AND201
* cell instance $47 r0 *1 4690.8,286.1
X$47 \$18 \$327 \$13 VSS INVR03
* cell instance $49 r0 *1 4682.57,108.7
X$49 \$254 \$14 \$212 \$18 VSS XNR201
* cell instance $52 r0 *1 4762.71,108.7
X$52 \$14 \$18 \$184 VSS INVR05
* cell instance $55 r180 *1 5039.48,246.1
X$55 \$18 \$15 \$101 VSS INVR06
* cell instance $57 m90 *1 5045.43,108.7
X$57 \$64 \$15 \$374 \$18 VSS XNR201
* cell instance $62 m0 *1 4801.37,68.7
X$62 \$28 \$59 \$15 \$60 \$27 \$58 \$18 VSS NND501
* cell instance $64 r180 *1 4964.3,68.7
X$64 \$18 \$174 \$16 VSS INVR02
* cell instance $66 m0 *1 4985.41,68.7
X$66 \$18 \$98 \$17 VSS INVR02
* cell instance $270 m90 *1 6411.08,5075.9
X$270 \$11966 \$10706 \$15711 \$9575 \$11972 \$18 VSS AOI401
* cell instance $273 m90 *1 6578.53,5075.9
X$273 \$8743 \$14962 \$15401 \$I331487 \$15583 \$18 VSS DFCL11
* cell instance $277 r0 *1 6604.06,5075.9
X$277 \$18 \$15716 \$15715 \$14157 VSS AND201
* cell instance $282 r0 *1 6648.93,5075.9
X$282 \$18 \$15717 \$15401 VSS INVR03
* cell instance $286 m90 *1 6709.65,5075.9
X$286 \$15157 \$18 \$15859 \$15159 VSS NOR201
* cell instance $290 r0 *1 6725.24,5075.9
X$290 \$18 \$15161 \$15163 VSS INVR02
* cell instance $296 m90 *1 6789.31,5075.9
X$296 \$15164 \$15718 \$18 \$14682 VSS OR2101
* cell instance $301 r0 *1 6821.78,5075.9
X$301 \$18 \$15166 \$15170 \$13651 VSS AND201
* cell instance $302 r0 *1 6846.98,5075.9
X$302 \$15170 \$18 \$15164 VSS INVR05
* cell instance $309 m90 *1 6927.52,5075.9
X$309 \$15168 \$14555 \$14682 \$18 VSS NND201
* cell instance $314 m90 *1 6983.15,5075.9
X$314 \$15720 \$18 \$14555 \$14682 VSS NOR201
* cell instance $315 m90 *1 6999.96,5075.9
X$315 \$18 \$15720 \$14967 VSS INVR02
* cell instance $331 r0 *1 7114.18,5075.9
X$331 \$15406 \$18 \$15597 VSS INVR05
* cell instance $437 r0 *1 7974.12,5075.9
X$437 \$18 \$15173 \$15406 VSS INVR04
* cell instance $550 m90 *1 3025.47,4366.3
X$550 \$18 \$18 \$11216 VSS INVR02
* cell instance $551 m0 *1 1165.35,4326.3
X$551 \$18 \$18 \$10755 VSS INVR02
* cell instance $552 m0 *1 4871.86,8761.3
X$552 \$18 \$18 \$20782 VSS INVR02
* cell instance $553 m0 *1 2167.04,3084.5
X$553 \$18 \$18 \$5466 VSS INVR02
* cell instance $554 r0 *1 124.21,3301.9
X$554 \$18 \$18 \$6310 VSS INVR02
* cell instance $555 r0 *1 240.61,2769.7
X$555 \$18 \$18 \$4690 VSS INVR02
* cell instance $556 r0 *1 88.2,4011.5
X$556 \$18 \$18 \$8521 VSS INVR02
* cell instance $557 r0 *1 2745.62,5075.9
X$557 \$18 \$18 \$14935 VSS INVR02
* cell instance $561 m90 *1 2246.86,4543.7
X$561 \$18 \$12240 \$12445 \$18 VSS AND201
* cell instance $563 r180 *1 2247.77,4503.7
X$563 \$18 \$11715 \$9509 \$18 VSS AND201
* cell instance $566 m0 *1 6199.76,4326.3
X$566 \$18 \$8058 \$7340 \$10482 \$10881 \$18 VSS DFCL11
* cell instance $568 r0 *1 2715.17,5075.9
X$568 \$14990 \$18 \$18 \$15836 VSS OR2101
* cell instance $574 m90 *1 3032.97,4898.5
X$574 \$18 \$18 \$15129 VSS INVR02
* cell instance $577 r0 *1 3019.8,4543.7
X$577 \$18 \$18 \$12328 VSS INVR04
* cell instance $586 r180 *1 2968.47,5390.7
X$586 \$17065 \$18 \$18 \$17066 VSS NOR201
* cell instance $588 m90 *1 3065.83,5430.7
X$588 \$18 \$18 \$11737 \$17369 VSS AND201
* cell instance $590 m0 *1 3057.04,5390.7
X$590 \$18 \$15569 \$18 \$10061 VSS OR2101
* cell instance $594 r0 *1 2892.11,5430.7
X$594 \$18 \$17365 \$18 \$17364 VSS OR2101
* cell instance $597 m90 *1 2363.33,5785.5
X$597 \$18 \$18100 \$18121 \$I331474 \$18427 \$18 VSS DFCL11
* cell instance $600 r180 *1 2295.85,5568.1
X$600 \$17732 \$18 \$18 \$17036 VSS NOR201
* cell instance $604 r0 *1 2333.11,5253.3
X$604 \$18 \$14080 \$18 VSS INVR03
* cell instance $610 r0 *1 2624.93,5430.7
X$610 \$18 \$17140 \$18 \$17195 VSS OR2101
* cell instance $616 r0 *1 2488.49,5253.3
X$616 \$16619 \$16617 \$18 \$18 VSS NND201
* cell instance $618 r0 *1 2305.82,5075.9
X$618 \$18 \$4161 \$I331279 \$15101 \$18 VSS DFFL11
* cell instance $634 r0 *1 2940.2,5253.3
X$634 \$18 \$16192 \$I331276 \$16320 \$18 VSS DFFL11
* cell instance $637 r0 *1 2993.9,5075.9
X$637 \$18 \$18 \$15841 VSS INVR06
* cell instance $640 r180 *1 2754.46,5390.7
X$640 \$16908 \$18 \$16627 \$18 VSS NND201
* cell instance $643 r0 *1 2899.36,4188.9
X$643 \$18 \$18 \$10067 VSS INVR02
* cell instance $647 m90 *1 1537.8,2237.5
X$647 \$18 \$2980 \$I331320 \$3143 \$18 VSS DFFL11
* cell instance $650 m90 *1 1379.41,2237.5
X$650 \$18 \$3227 \$3066 \$I331726 \$2976 \$18 VSS DFPR11
* cell instance $653 m90 *1 3051.1,4366.3
X$653 \$18 \$11086 \$18 VSS INVR02
* cell instance $655 m0 *1 1250.16,2729.7
X$655 \$18 \$4270 \$I331297 \$4351 \$18 VSS DFFL11
* cell instance $660 m90 *1 1468.98,2947.1
X$660 \$18 \$4450 \$I331314 \$4615 \$18 VSS DFFL11
* cell instance $663 m90 *1 1542.1,2769.7
X$663 \$18 \$4349 \$4550 \$I331495 \$4549 \$18 VSS DFCL11
* cell instance $670 m90 *1 1488.44,2592.3
X$670 \$18 \$4207 \$3891 \$4346 \$4120 \$18 VSS DFCL11
* cell instance $674 m0 *1 2135.83,2552.3
X$674 \$18 \$18 \$3914 VSS INVR02
* cell instance $679 r180 *1 1483.29,2374.9
X$679 \$18 \$3297 \$I331284 \$3409 \$18 VSS DFFL11
* cell instance $682 r180 *1 2041.74,2552.3
X$682 \$18 \$3825 \$3979 \$3738 \$3737 \$18 VSS DFCL11
* cell instance $690 m90 *1 1835.37,2769.7
X$690 \$18 \$4555 \$I331315 \$4554 \$18 VSS DFFL11
* cell instance $692 m90 *1 1901.2,3124.5
X$692 \$18 \$3825 \$5455 \$5697 \$4908 \$18 VSS DFCL11
* cell instance $695 m0 *1 1238.64,2907.1
X$695 \$18 \$4454 \$4980 \$I331431 \$5051 \$18 VSS DFCL11
* cell instance $699 m0 *1 1620.04,2907.1
X$699 \$18 \$4454 \$5251 \$I331449 \$4679 \$18 VSS DFCL11
* cell instance $702 r0 *1 2886.45,4011.5
X$702 \$18 \$9024 \$18 VSS INVR02
* cell instance $707 m0 *1 1519.23,3261.9
X$707 \$18 \$5891 \$6279 \$I331426 \$6123 \$18 VSS DFCL11
* cell instance $710 m0 *1 1347.17,3261.9
X$710 \$18 \$5851 \$6021 \$I331405 \$6023 \$18 VSS DFCL11
* cell instance $712 r180 *1 3845.71,4503.7
X$712 \$18 \$11590 \$11727 \$I331719 \$11933 \$18 VSS DFPR11
* cell instance $719 m0 *1 2178.46,3261.9
X$719 \$18 \$18 \$6056 \$I331439 \$6057 \$18 VSS DFCL11
* cell instance $722 m0 *1 4285.32,4148.9
X$722 \$8743 \$9036 \$18 \$I331462 \$9551 \$18 VSS DFCL11
* cell instance $724 m0 *1 4121.55,8583.9
X$724 \$18 \$19393 \$20534 \$I331725 \$20535 \$18 VSS DFPR11
* cell instance $728 r0 *1 5225.8,4366.3
X$728 \$18 \$8619 \$18 \$I331333 \$10698 \$18 VSS DFCL11
* cell instance $734 r180 *1 4494.77,2552.3
X$734 \$18 \$2816 \$3988 \$I331382 \$3752 \$18 VSS DFCL11
* cell instance $739 m90 *1 4964.36,2237.5
X$739 \$18 \$1308 \$I331318 \$3098 \$18 VSS DFFL11
* cell instance $742 m0 *1 4400.19,3439.3
X$742 \$18 \$3041 \$3039 \$I331404 \$6556 \$18 VSS DFCL11
* cell instance $744 r180 *1 4914.21,2374.9
X$744 \$18 \$2502 \$3273 \$I331375 \$3464 \$18 VSS DFCL11
* cell instance $746 m90 *1 2023.05,2414.9
X$746 \$18 \$3742 \$3428 \$3427 \$18 VSS DFFL11
* cell instance $748 r0 *1 2023.05,2414.9
X$748 \$18 \$3743 \$18 \$I331330 \$3656 \$18 VSS DFCL11
* cell instance $751 m90 *1 2028.28,2237.5
X$751 \$18 \$3073 \$3108 \$3071 \$18 VSS DFFL11
* cell instance $755 r180 *1 4484.01,3261.9
X$755 \$18 \$3933 \$3260 \$I331379 \$5793 \$18 VSS DFCL11
* cell instance $757 m0 *1 4484.01,3261.9
X$757 \$18 \$5947 \$6139 \$I331456 \$5794 \$18 VSS DFCL11
* cell instance $763 m0 *1 4740.51,2552.3
X$763 \$18 \$3691 \$3944 \$I331460 \$3379 \$18 VSS DFCL11
* cell instance $767 m90 *1 1910.94,2237.5
X$767 \$18 \$2771 \$I331309 \$3241 \$18 VSS DFFL11
* cell instance $769 m0 *1 1238.56,4858.5
X$769 \$18 \$12423 \$13419 \$I331436 \$13557 \$18 VSS DFCL11
* cell instance $773 r180 *1 159.3,5390.7
X$773 \$18 \$17382 \$16980 \$I331399 \$16505 \$18 VSS DFCL11
* cell instance $775 m90 *1 158.12,5430.7
X$775 \$18 \$17382 \$17254 \$17599 \$17293 \$18 VSS DFCL11
* cell instance $777 r0 *1 364.72,5430.7
X$777 \$18 \$17215 \$17212 \$17677 \$17302 \$18 VSS DFCL11
* cell instance $781 m90 *1 245.76,5075.9
X$781 \$18 \$15025 \$14574 \$14574 \$7474 \$18 VSS DFPR11
* cell instance $784 m0 *1 65.93,5035.9
X$784 \$18 \$14574 \$18 \$I331442 \$14439 \$18 VSS DFCL11
* cell instance $788 r180 *1 166.22,5213.3
X$788 \$18 \$15910 \$14574 \$I331720 \$16068 \$18 VSS DFPR11
* cell instance $791 r180 *1 289.07,4681.1
X$791 \$18 \$12730 \$12387 \$12852 \$I331194 \$18 VSS DFPR11
* cell instance $796 r180 *1 265.66,4503.7
X$796 \$18 \$11561 \$11817 \$I331370 \$11114 \$18 VSS DFCL11
* cell instance $798 m90 *1 282.44,4543.7
X$798 \$18 \$12388 \$9419 \$I331728 \$11112 \$18 VSS DFPR11
* cell instance $801 m0 *1 51,4858.5
X$801 \$18 \$13837 \$13838 \$I331434 \$14012 \$18 VSS DFCL11
* cell instance $805 r0 *1 606.27,5608.1
X$805 \$18 \$17215 \$17955 \$I331348 \$18048 \$18 VSS DFCL11
* cell instance $810 m90 *1 1340.23,4543.7
X$810 \$18 \$12423 \$12165 \$I331472 \$12285 \$18 VSS DFCL11
* cell instance $813 m90 *1 4238.18,995.7
X$813 \$18 \$1140 \$I331322 \$1110 \$18 VSS DFFL11
* cell instance $816 m90 *1 4255.89,818.3
X$816 \$18 \$20 \$I331307 \$934 \$18 VSS DFFL11
* cell instance $819 m0 *1 4383.85,955.7
X$819 \$18 \$764 \$1080 \$I331421 \$938 \$18 VSS DFCL11
* cell instance $823 m90 *1 858.34,5608.1
X$823 \$18 \$17397 \$18050 \$I331493 \$17306 \$18 VSS DFCL11
* cell instance $828 r180 *1 1098.41,5213.3
X$828 \$18 \$15941 \$15640 \$I331721 \$16103 \$18 VSS DFPR11
* cell instance $830 r180 *1 984.93,5213.3
X$830 \$18 \$15639 \$15935 \$I331364 \$15631 \$18 VSS DFCL11
* cell instance $833 m90 *1 1225.32,4721.1
X$833 \$13415 \$18 \$12421 \$18 VSS NND201
* cell instance $835 r0 *1 482.81,5430.7
X$835 \$18 \$17215 \$16999 \$I331342 \$16535 \$18 VSS DFCL11
* cell instance $841 m90 *1 706.67,5430.7
X$841 \$18 \$17397 \$17218 \$I331468 \$17304 \$18 VSS DFCL11
* cell instance $845 m0 *1 4392.76,1133.1
X$845 \$18 \$764 \$1288 \$I331435 \$1290 \$18 VSS DFCL11
* cell instance $850 r180 *1 1204.91,5390.7
X$850 \$18 \$16889 \$17014 \$I331722 \$17013 \$18 VSS DFPR11
* cell instance $854 m0 *1 4198.63,1310.5
X$854 \$18 \$1443 \$1607 \$I331448 \$1502 \$18 VSS DFCL11
* cell instance $856 r180 *1 4198.63,1310.5
X$856 \$18 \$1525 \$1400 \$I331367 \$1440 \$18 VSS DFCL11
* cell instance $860 r0 *1 1378.26,5075.9
X$860 \$18 \$13747 \$15442 \$I331328 \$15515 \$18 VSS DFCL11
* cell instance $863 m90 *1 4214.4,1173.1
X$863 \$18 \$1436 \$I331317 \$1437 \$18 VSS DFFL11
* cell instance $872 r180 *1 1526.5,5390.7
X$872 \$18 \$13747 \$17027 \$I331397 \$16292 \$18 VSS DFCL11
* cell instance $874 m90 *1 1519.76,5430.7
X$874 \$18 \$16721 \$17225 \$I331470 \$17328 \$18 VSS DFCL11
* cell instance $879 r0 *1 1426.56,5253.3
X$879 \$18 \$16721 \$16414 \$I331332 \$16575 \$18 VSS DFCL11
* cell instance $882 m0 *1 4099.25,1133.1
X$882 \$18 \$1236 \$1277 \$I331427 \$1278 \$18 VSS DFCL11
* cell instance $886 r0 *1 4126.57,1350.5
X$886 \$18 \$1525 \$1627 \$I331340 \$1569 \$18 VSS DFCL11
* cell instance $892 r180 *1 4096.01,1487.9
X$892 \$18 \$1790 \$1974 \$I331380 \$1820 \$18 VSS DFCL11
* cell instance $895 m90 *1 4328.17,1350.5
X$895 \$18 \$1525 \$1625 \$I331464 \$1668 \$18 VSS DFCL11
* cell instance $897 m0 *1 3901.83,1133.1
X$897 \$18 \$1075 \$1130 \$I331441 \$1274 \$18 VSS DFCL11
* cell instance $901 m90 *1 4112.87,1527.9
X$901 \$18 \$1525 \$1918 \$I331488 \$1946 \$18 VSS DFCL11
* cell instance $905 m90 *1 900.69,4543.7
X$905 \$18 \$11561 \$12028 \$I331469 \$12155 \$18 VSS DFCL11
* cell instance $907 r180 *1 1081.9,4681.1
X$907 \$18 \$10813 \$11573 \$I331389 \$12890 \$18 VSS DFCL11
* cell instance $910 r0 *1 838.22,4721.1
X$910 \$12866 \$18 \$18 \$13326 VSS OR2101
* cell instance $913 m0 *1 974.92,4858.5
X$913 \$18 \$13747 \$14049 \$I331424 \$14050 \$18 VSS DFCL11
* cell instance $917 m90 *1 1077.46,4898.5
X$917 \$18 \$13412 \$14393 \$14049 \$14596 \$18 VSS DFPR11
* cell instance $919 m0 *1 889.88,4858.5
X$919 \$18 \$18 \$14044 VSS INVR03
* cell instance $922 r0 *1 1673.6,5075.9
X$922 \$18 \$9428 \$15519 \$15077 \$18 VSS DFFL11
* cell instance $925 m90 *1 1904.6,5075.9
X$925 \$18 \$13089 \$12425 \$I331477 \$15520 \$18 VSS DFCL11
* cell instance $930 m90 *1 1876.26,5430.7
X$930 \$18 \$16587 \$17226 \$I331463 \$16731 \$18 VSS DFCL11
* cell instance $932 m90 *1 1897.38,5253.3
X$932 \$18 \$16140 \$16420 \$I331465 \$15074 \$18 VSS DFCL11
* cell instance $934 r0 *1 2119.03,5075.9
X$934 \$18 \$18 \$15255 VSS INVR06
* cell instance $937 r180 *1 932.2,4681.1
X$937 \$18 \$11139 \$10016 \$11130 \$I330176 \$18 VSS DFCL11
* cell instance $940 r180 *1 1576.8,5922.9
X$940 \$18 \$18699 \$18620 \$I331394 \$18694 \$18 VSS DFCL11
* cell instance $944 r180 *1 1145.06,6100.3
X$944 \$18 \$19339 \$18813 \$I331715 \$19385 \$18 VSS DFPR11
* cell instance $946 r180 *1 1261.87,6277.7
X$946 \$18 \$7694 \$I331293 \$19590 \$18 VSS DFFL11
* cell instance $952 r0 *1 1486.14,6140.3
X$952 \$18 \$19646 \$19597 \$19597 \$19473 \$18 VSS DFPR11
* cell instance $955 r180 *1 1594.83,6277.7
X$955 \$18 \$18699 \$19767 \$I331371 \$19765 \$18 VSS DFCL11
* cell instance $961 m90 *1 2075.31,5785.5
X$961 \$18 \$18626 \$18114 \$I331481 \$18627 \$18 VSS DFCL11
* cell instance $963 r180 *1 2075.09,5922.9
X$963 \$18 \$18852 \$18975 \$I331381 \$18973 \$18 VSS DFCL11
* cell instance $966 r180 *1 1484.19,5568.1
X$966 \$18 \$16721 \$17821 \$I331366 \$17817 \$18 VSS DFCL11
* cell instance $970 m90 *1 1931.86,5785.5
X$970 \$18 \$18424 \$17437 \$I331479 \$17720 \$18 VSS DFCL11
* cell instance $973 m90 *1 1822.65,5785.5
X$973 \$18 \$18699 \$18088 \$I331505 \$18622 \$18 VSS DFCL11
* cell instance $976 m0 *1 1747.65,5922.9
X$976 \$18 \$18849 \$18966 \$I331438 \$18969 \$18 VSS DFCL11
* cell instance $978 r180 *1 1208.67,5745.5
X$978 \$18 \$18292 \$18294 \$I331716 \$18394 \$18 VSS DFPR11
* cell instance $982 r180 *1 1579.76,5745.5
X$982 \$18 \$18192 \$18080 \$I331362 \$18407 \$18 VSS DFCL11
* cell instance $984 r180 *1 1223.86,5568.1
X$984 \$18 \$17529 \$17698 \$I331714 \$17697 \$18 VSS DFPR11
* cell instance $986 r180 *1 1835.14,4681.1
X$986 \$18 \$11161 \$13096 \$I331365 \$12908 \$18 VSS DFCL11
* cell instance $990 r180 *1 1862.27,4503.7
X$990 \$18 \$11577 \$12299 \$I331377 \$11872 \$18 VSS DFCL11
* cell instance $993 m90 *1 1856.82,4721.1
X$993 \$18 \$13575 \$13275 \$I331496 \$13427 \$18 VSS DFCL11
* cell instance $1003 r180 *1 2007.5,6277.7
X$1003 \$18 \$18100 \$17240 \$I331376 \$17970 \$18 VSS DFCL11
* cell instance $1008 r0 *1 1700.69,6140.3
X$1008 \$18 \$19650 \$19601 \$I331327 \$19602 \$18 VSS DFCL11
* cell instance $1011 m0 *1 4210.4,1842.7
X$1011 \$18 \$2350 \$2410 \$I331415 \$2411 \$18 VSS DFCL11
* cell instance $1013 r0 *1 4208.06,1882.7
X$1013 \$18 \$2350 \$2136 \$I331347 \$2517 \$18 VSS DFCL11
* cell instance $1018 m90 *1 1870.79,4898.5
X$1018 \$18 \$14614 \$14326 \$I331471 \$14482 \$18 VSS DFCL11
* cell instance $1020 m0 *1 4011.75,1842.7
X$1020 \$18 \$2350 \$2405 \$I331455 \$2271 \$18 VSS DFCL11
* cell instance $1023 r180 *1 4378.99,2020.1
X$1023 \$18 \$18 \$I331292 \$2695 \$18 VSS DFFL11
* cell instance $1027 r180 *1 1856.81,4858.5
X$1027 \$18 \$12912 \$11892 \$I331392 \$14070 \$18 VSS DFCL11
* cell instance $1032 m0 *1 383.95,5922.9
X$1032 \$18 \$18753 \$18915 \$18818 \$18917 \$18 VSS DFCL11
* cell instance $1034 m90 *1 386.21,5962.9
X$1034 \$18 \$15639 \$17120 \$I331503 \$19056 \$18 VSS DFCL11
* cell instance $1039 m90 *1 487.01,5962.9
X$1039 \$18 \$18753 \$19059 \$I331506 \$19140 \$18 VSS DFCL11
* cell instance $1042 m90 *1 168.03,5785.5
X$1042 \$18 \$18668 \$16511 \$I331500 \$18356 \$18 VSS DFCL11
* cell instance $1046 r180 *1 176.82,5922.9
X$1046 \$18 \$18574 \$18813 \$I331717 \$18812 \$18 VSS DFPR11
* cell instance $1048 r0 *1 615.25,5785.5
X$1048 \$18 \$18582 \$18527 \$I331331 \$17689 \$18 VSS DFCL11
* cell instance $1057 m0 *1 609.09,5922.9
X$1057 \$18 \$18821 \$18680 \$I331432 \$18678 \$18 VSS DFCL11
* cell instance $1067 r0 *1 3944.39,818.3
X$1067 \$18 \$883 \$839 \$I331326 \$974 \$18 VSS DFCL11
* cell instance $1074 r180 *1 1108.98,5922.9
X$1074 \$18 \$15493 \$15639 \$15639 \$17008 \$18 VSS DFPR11
* cell instance $1076 r180 *1 1008.18,5922.9
X$1076 \$18 \$18762 \$18582 \$I331718 \$18685 \$18 VSS DFPR11
* cell instance $1078 r0 *1 4334.46,640.9
X$1078 \$18 \$764 \$586 \$I331339 \$447 \$18 VSS DFCL11
* cell instance $1080 m90 *1 4327.06,640.9
X$1080 \$18 \$764 \$673 \$I331475 \$674 \$18 VSS DFCL11
* cell instance $1085 m0 *1 567.69,6100.3
X$1085 \$18 \$18753 \$19437 \$5730 \$19146 \$18 VSS DFCL11
* cell instance $1088 m0 *1 668.49,6100.3
X$1088 \$18 \$19150 \$19440 \$I331413 \$19376 \$18 VSS DFCL11
* cell instance $1090 r0 *1 580.73,6140.3
X$1090 \$18 \$19150 \$19570 \$I331341 \$19571 \$18 VSS DFCL11
* cell instance $1093 m0 *1 1391.81,4503.7
X$1093 \$18 \$11702 \$18 \$11858 VSS AND201
* cell instance $1096 m0 *1 908.1,6100.3
X$1096 \$18 \$19359 \$12416 \$19337 \$I330196 \$18 VSS DFCL11
* cell instance $1101 r180 *1 1084.72,6277.7
X$1101 \$18 \$19707 \$19384 \$19384 \$19164 \$18 VSS DFPR11
* cell instance $1103 m0 *1 1777.16,5568.1
X$1103 \$18 \$16587 \$17727 \$I331457 \$17832 \$18 VSS DFCL11
* cell instance $1105 m90 *1 2169.63,4898.5
X$1105 \$18 \$14625 \$14291 \$I331473 \$14075 \$18 VSS DFCL11
* cell instance $1112 m0 *1 4343.26,68.7
X$1112 \$18 \$18 \$39 VSS INVR06
* cell instance $1116 m90 *1 485.99,6317.7
X$1116 \$18 \$19809 \$I331312 \$19808 \$18 VSS DFFL11
* cell instance $1121 r180 *1 1130.41,4326.3
X$1121 \$18 \$10204 \$9668 \$I331368 \$10026 \$18 VSS DFCL11
* cell instance $1126 r0 *1 1313.57,4366.3
X$1126 \$18 \$10815 \$18 VSS INVR03
* cell instance $1128 r0 *1 881.87,3479.3
X$1128 \$18 \$18 \$6609 VSS INVR04
* cell instance $1133 r180 *1 1179.97,4148.9
X$1133 \$18 \$9310 \$9468 \$I331391 \$8973 \$18 VSS DFCL11
* cell instance $1136 m90 *1 651.06,3479.3
X$1136 \$18 \$6242 \$I331311 \$6782 \$18 VSS DFFL11
* cell instance $1139 m90 *1 783.39,3479.3
X$1139 \$18 \$6972 \$6790 \$I331729 \$6859 \$18 VSS DFPR11
* cell instance $1143 m0 *1 782.85,3261.9
X$1143 \$18 \$5916 \$6001 \$I331411 \$6002 \$18 VSS DFCL11
* cell instance $1145 m0 *1 573.15,3261.9
X$1145 \$18 \$2767 \$I331302 \$5996 \$18 VSS DFFL11
* cell instance $1148 r180 *1 998.1,3439.3
X$1148 \$18 \$6523 \$6610 \$I331384 \$6522 \$18 VSS DFCL11
* cell instance $1152 r180 *1 2297.41,3439.3
X$1152 \$18 \$6382 \$6650 \$I331386 \$6649 \$18 VSS DFCL11
* cell instance $1154 r0 *1 1380.48,3656.7
X$1154 \$18 \$7410 \$18 VSS INVR04
* cell instance $1157 m0 *1 1339.76,3794.1
X$1157 \$18 \$18 \$7887 VSS INVR03
* cell instance $1161 m0 *1 1591.31,3971.5
X$1161 \$18 \$8438 \$I331298 \$8580 \$18 VSS DFFL11
* cell instance $1164 m90 *1 1146.71,4011.5
X$1164 \$18 \$4613 \$I331306 \$8557 \$18 VSS DFFL11
* cell instance $1166 m90 *1 1196.35,3834.1
X$1166 \$18 \$7040 \$7881 \$8157 \$I330265 \$18 VSS DFCL11
* cell instance $1169 m90 *1 737.11,3656.7
X$1169 \$18 \$6165 \$6789 \$I331483 \$7495 \$18 VSS DFCL11
* cell instance $1171 m0 *1 1378.59,3794.1
X$1171 \$18 \$7606 \$18 VSS INVR03
* cell instance $1174 m0 *1 115.47,3261.9
X$1174 \$18 \$18 \$5720 VSS INVR04
* cell instance $1177 m0 *1 4458.12,600.9
X$1177 \$18 \$556 \$525 \$I331451 \$730 \$18 VSS DFCL11
* cell instance $1179 r0 *1 4696.95,640.9
X$1179 \$18 \$556 \$711 \$I331356 \$724 \$18 VSS DFCL11
* cell instance $1181 m90 *1 2083.5,3834.1
X$1181 \$18 \$7819 \$8037 \$7817 \$I330264 \$18 VSS DFCL11
* cell instance $1185 r0 *1 4474.16,463.5
X$1185 \$18 \$556 \$415 \$I331350 \$613 \$18 VSS DFCL11
* cell instance $1187 m90 *1 4675.76,463.5
X$1187 \$18 \$556 \$557 \$I331494 \$574 \$18 VSS DFCL11
* cell instance $1197 m90 *1 4787.89,463.5
X$1197 \$18 \$556 \$559 \$I331480 \$592 \$18 VSS DFCL11
* cell instance $1200 r180 *1 251.94,3261.9
X$1200 \$18 \$5581 \$18 VSS INVR04
* cell instance $1208 r180 *1 236.19,2907.1
X$1208 \$18 \$18 \$I331294 \$4872 \$18 VSS DFFL11
* cell instance $1211 r0 *1 128.31,2769.7
X$1211 \$18 \$18 \$4081 VSS INVR05
* cell instance $1216 r180 *1 5266.95,600.9
X$1216 \$18 \$609 \$542 \$I331396 \$603 \$18 VSS DFCL11
* cell instance $1221 m90 *1 4477.63,818.3
X$1221 \$18 \$597 \$413 \$I331478 \$885 \$18 VSS DFCL11
* cell instance $1224 m0 *1 254.72,3084.5
X$1224 \$18 \$5316 \$5392 \$4587 \$5519 \$18 VSS DFCL11
* cell instance $1230 r0 *1 5213.98,463.5
X$1230 \$18 \$600 \$440 \$I331323 \$544 \$18 VSS DFCL11
* cell instance $1238 r0 *1 5029.3,463.5
X$1238 \$18 \$600 \$537 \$I331329 \$433 \$18 VSS DFCL11
* cell instance $1240 m0 *1 2245.88,3794.1
X$1240 \$18 \$6055 \$7555 \$7553 \$7559 \$18 VSS DFCL11
* cell instance $1246 r180 *1 2289.54,3616.7
X$1246 \$18 \$3743 \$6648 \$I331383 \$6908 \$18 VSS DFCL11
* cell instance $1249 m0 *1 1067.71,2907.1
X$1249 \$18 \$4207 \$4895 \$I331428 \$4612 \$18 VSS DFCL11
* cell instance $1252 m0 *1 966.91,2907.1
X$1252 \$18 \$4744 \$5039 \$I331425 \$4894 \$18 VSS DFCL11
* cell instance $1256 r180 *1 510.92,3084.5
X$1256 \$18 \$3393 \$I331290 \$4970 \$18 VSS DFFL11
* cell instance $1261 r180 *1 482.59,3261.9
X$1261 \$18 \$5909 \$I331285 \$5729 \$18 VSS DFFL11
* cell instance $1269 r180 *1 307.71,4326.3
X$1269 \$18 \$9994 \$10564 \$I331393 \$10562 \$18 VSS DFCL11
* cell instance $1274 m90 *1 2235.07,3124.5
X$1274 \$18 \$5473 \$I331308 \$18 \$18 VSS DFFL11
* cell instance $1276 r180 *1 804.43,3971.5
X$1276 \$18 \$6165 \$7260 \$I331374 \$8365 \$18 VSS DFCL11
* cell instance $1278 r0 *1 2247.33,3124.5
X$1278 \$18 \$5786 \$5468 \$5475 \$18 VSS DFFL11
* cell instance $1280 m0 *1 2341.89,3261.9
X$1280 \$18 \$18 \$5941 VSS INVR02
* cell instance $1286 r180 *1 2347.19,2729.7
X$1286 \$18 \$4279 \$4278 \$4475 \$18 VSS DFFL11
* cell instance $1294 m0 *1 83.09,3971.5
X$1294 \$18 \$7329 \$8523 \$I331443 \$7469 \$18 VSS DFCL11
* cell instance $1297 r0 *1 51.61,3834.1
X$1297 \$18 \$6310 \$7136 \$8115 \$8116 \$18 VSS DFCL11
* cell instance $1302 r0 *1 141.6,4011.5
X$1302 \$18 \$8261 \$18 VSS INVR06
* cell instance $1307 m0 *1 2017.42,3439.3
X$1307 \$18 \$18 \$6045 VSS INVR02
* cell instance $1310 r0 *1 2058.59,3479.3
X$1310 \$18 \$18 \$6826 VSS INVR06
* cell instance $1313 r0 *1 973.41,4366.3
X$1313 \$18 \$11139 \$18 VSS INVR04
* cell instance $1315 r0 *1 959.87,4188.9
X$1315 \$18 \$6758 \$18 VSS INVR03
* cell instance $1320 r0 *1 1894.9,3479.3
X$1320 \$18 \$18 \$6821 \$I331357 \$6823 \$18 VSS DFCL11
* cell instance $1324 r180 *1 1926,3439.3
X$1324 \$18 \$6041 \$6642 \$6354 \$6358 \$18 VSS DFCL11
* cell instance $1331 r0 *1 721.14,4011.5
X$1331 \$18 \$5916 \$8829 \$I331345 \$8831 \$18 VSS DFCL11
* cell instance $1336 r0 *1 901.5,4188.9
X$1336 \$18 \$18 \$10017 VSS INVR02
* cell instance $1338 r0 *1 820.7,4188.9
X$1338 \$18 \$18 \$9460 VSS INVR06
* cell instance $1340 r0 *1 881.23,4188.9
X$1340 \$18 \$10017 \$18 VSS INVR02
* cell instance $1345 m0 *1 861.41,4326.3
X$1345 \$18 \$10320 \$10586 \$I331724 \$10587 \$18 VSS DFPR11
* cell instance $1348 r0 *1 1101.32,4366.3
X$1348 \$18 \$11349 \$11089 \$I331712 \$11148 \$18 VSS DFPR11
* cell instance $1350 m0 *1 983.41,4326.3
X$1350 \$18 \$18 \$10204 VSS INVR02
* cell instance $1353 r180 *1 255.04,3616.7
X$1353 \$18 \$7040 \$6967 \$7034 \$6963 \$18 VSS DFCL11
* cell instance $1361 r0 *1 114.46,3479.3
X$1361 \$18 \$18 \$6768 VSS INVR03
* cell instance $1363 r0 *1 163.41,3479.3
X$1363 \$18 \$18 \$6769 VSS INVR04
* cell instance $1366 m0 *1 343.84,3616.7
X$1366 \$18 \$6769 \$7248 \$I331417 \$6592 \$18 VSS DFCL11
* cell instance $1368 r180 *1 558.07,3616.7
X$1368 \$18 \$6852 \$7250 \$I331385 \$6853 \$18 VSS DFCL11
* cell instance $1372 r180 *1 1101.74,3794.1
X$1372 \$18 \$7701 \$7879 \$I331390 \$7878 \$18 VSS DFCL11
* cell instance $1377 m90 *1 962.22,3656.7
X$1377 \$18 \$7500 \$7407 \$I331501 \$7405 \$18 VSS DFCL11
* cell instance $1379 r0 *1 141.61,3301.9
X$1379 \$18 \$18 \$6223 VSS INVR06
* cell instance $1382 m0 *1 1521.44,3439.3
X$1382 \$18 \$4618 \$I331303 \$6467 \$18 VSS DFFL11
* cell instance $1384 m0 *1 338.4,3439.3
X$1384 \$18 \$6106 \$I331296 \$6588 \$18 VSS DFFL11
* cell instance $1389 m90 *1 460.26,3479.3
X$1389 \$18 \$6758 \$18 \$I331466 \$6589 \$18 VSS DFCL11
* cell instance $1399 r180 *1 4718.02,8761.3
X$1399 \$20801 \$20569 \$20865 \$18 \$20205 \$19995 \$18 VSS NND501
* cell instance $1405 r0 *1 277.44,2414.9
X$1405 \$18 \$3707 \$3611 \$3565 \$18 VSS DFFL11
* cell instance $1410 m90 *1 4717.88,2060.1
X$1410 \$18 \$2555 \$I331304 \$2556 \$18 VSS DFFL11
* cell instance $1412 m90 *1 4861.82,2060.1
X$1412 \$2529 \$2428 \$18 \$18 \$2441 VSS NOR301
* cell instance $1417 m0 *1 864.13,2552.3
X$1417 \$18 \$925 \$3877 \$I331453 \$3874 \$18 VSS DFCL11
* cell instance $1421 r0 *1 964.1,2592.3
X$1421 \$18 \$3723 \$I331283 \$4116 \$18 VSS DFFL11
* cell instance $1425 m90 *1 5092.07,1705.3
X$1425 \$18 \$2098 \$2194 \$I331482 \$2246 \$18 VSS DFCL11
* cell instance $1429 m90 *1 5093.18,2060.1
X$1429 \$18 \$2592 \$I331305 \$2821 \$18 VSS DFFL11
* cell instance $1435 r0 *1 193.44,2414.9
X$1435 \$18 \$3706 \$I331273 \$3391 \$18 VSS DFFL11
* cell instance $1437 m0 *1 4998.51,1665.3
X$1437 \$18 \$2098 \$1714 \$I331454 \$2164 \$18 VSS DFCL11
* cell instance $1439 m0 *1 4740.25,1842.7
X$1439 \$18 \$2161 \$2245 \$I331459 \$1856 \$18 VSS DFCL11
* cell instance $1441 m90 *1 2120.39,4366.3
X$1441 \$18 \$10045 \$11020 \$I331467 \$10825 \$18 VSS DFCL11
* cell instance $1446 r0 *1 1107.15,2592.3
X$1446 \$18 \$3637 \$I331275 \$4118 \$18 VSS DFFL11
* cell instance $1448 r180 *1 4329.26,2552.3
X$1448 \$18 \$3369 \$3673 \$I331372 \$3934 \$18 VSS DFCL11
* cell instance $1452 r180 *1 4706.09,2020.1
X$1452 \$18 \$2620 \$I331288 \$2523 \$18 VSS DFFL11
* cell instance $1456 r180 *1 4914.37,1842.7
X$1456 \$1963 \$18 \$18 VSS INVR05
* cell instance $1459 r180 *1 4933.42,1842.7
X$1459 \$18 \$2436 \$18 VSS INVR03
* cell instance $1461 r0 *1 4987.25,1882.7
X$1461 \$18 \$2502 \$2501 \$I331324 \$2541 \$18 VSS DFCL11
* cell instance $1463 r0 *1 2222.39,4011.5
X$1463 \$18 \$6382 \$7549 \$6916 \$7923 \$18 VSS DFCL11
* cell instance $1467 m0 *1 2024.84,3084.5
X$1467 \$18 \$5262 \$I331299 \$5263 \$18 VSS DFFL11
* cell instance $1470 r180 *1 2016.43,3084.5
X$1470 \$18 \$5165 \$5162 \$3655 \$18 VSS DFFL11
* cell instance $1475 m0 *1 5565.01,4858.5
X$1475 \$18 \$13634 \$18 VSS INVR02
* cell instance $1482 m0 *1 5544.01,4858.5
X$1482 \$18 \$14146 \$18 VSS INVR04
* cell instance $1484 m0 *1 668.02,2552.3
X$1484 \$18 \$3402 \$I331301 \$3064 \$18 VSS DFFL11
* cell instance $1488 m90 *1 595.9,2237.5
X$1488 \$18 \$3213 \$I331316 \$2970 \$18 VSS DFFL11
* cell instance $1490 m0 *1 5432.72,4681.1
X$1490 \$18 \$6749 \$7470 \$I331419 \$13156 \$18 VSS DFCL11
* cell instance $1493 r180 *1 650.61,2374.9
X$1493 \$18 \$3295 \$I331289 \$3395 \$18 VSS DFFL11
* cell instance $1499 m0 *1 421.69,2552.3
X$1499 \$18 \$3711 \$I331295 \$3868 \$18 VSS DFFL11
* cell instance $1504 m0 *1 337.69,2552.3
X$1504 \$18 \$3814 \$I331300 \$3866 \$18 VSS DFFL11
* cell instance $1507 r0 *1 1867.98,3834.1
X$1507 \$18 \$7815 \$8035 \$7816 \$8036 \$18 VSS DFCL11
* cell instance $1510 m0 *1 1700.51,3971.5
X$1510 \$18 \$7814 \$8582 \$8441 \$8854 \$18 VSS DFCL11
* cell instance $1513 r0 *1 1740.71,3834.1
X$1513 \$18 \$8170 \$7176 \$I331343 \$7903 \$18 VSS DFCL11
* cell instance $1515 m90 *1 2222.39,4011.5
X$1515 \$18 \$9001 \$6915 \$I331504 \$9115 \$18 VSS DFCL11
* cell instance $1517 r0 *1 2394.8,3834.1
X$1517 \$18 \$6382 \$7564 \$7198 \$8202 \$18 VSS DFCL11
* cell instance $1520 m90 *1 4981.22,1173.1
X$1520 \$18 \$1463 \$I331319 \$1415 \$18 VSS DFFL11
* cell instance $1523 r0 *1 5215.58,995.7
X$1523 \$18 \$870 \$958 \$I331346 \$961 \$18 VSS DFCL11
* cell instance $1525 m90 *1 5018.19,463.5
X$1525 \$18 \$597 \$536 \$I331502 \$617 \$18 VSS DFCL11
* cell instance $1527 r0 *1 294.27,2947.1
X$1527 \$18 \$5118 \$4966 \$I331352 \$5024 \$18 VSS DFCL11
* cell instance $1529 m0 *1 5181.63,778.3
X$1529 \$18 \$609 \$750 \$I331406 \$793 \$18 VSS DFCL11
* cell instance $1535 r0 *1 5273.8,1350.5
X$1535 \$18 \$1755 \$1645 \$I331358 \$1646 \$18 VSS DFCL11
* cell instance $1538 m90 *1 409.19,2592.3
X$1538 \$18 \$4189 \$I331321 \$4089 \$18 VSS DFFL11
* cell instance $1540 r0 *1 516.52,2592.3
X$1540 \$18 \$3622 \$I331282 \$4100 \$18 VSS DFFL11
* cell instance $1542 m0 *1 5269.77,1133.1
X$1542 \$18 \$1256 \$1347 \$I331429 \$1172 \$18 VSS DFCL11
* cell instance $1544 r0 *1 5284.83,1173.1
X$1544 \$18 \$1256 \$1376 \$I331359 \$1424 \$18 VSS DFCL11
* cell instance $1546 m0 *1 4451.83,1487.9
X$1546 \$18 \$702 \$1167 \$I331423 \$1837 \$18 VSS DFCL11
* cell instance $1563 r180 *1 45.19,4858.5
X$1563 \$18 \$13836 \$13509 VSS INVR02
* cell instance $1569 m0 *1 166.96,4858.5
X$1569 \$14014 \$14012 \$14439 \$18 VSS NND201
* cell instance $1571 m0 *1 183.76,4858.5
X$1571 \$18 \$11115 \$14015 VSS INVR03
* cell instance $1576 r180 *1 255.5,4858.5
X$1576 \$12389 \$13839 \$18 \$13518 VSS OR2101
* cell instance $1580 r180 *1 289.39,4858.5
X$1580 \$14017 \$14019 \$14018 \$18 VSS NND201
* cell instance $1583 r180 *1 328.43,4858.5
X$1583 \$14020 \$18 \$13549 \$14017 VSS NOR201
* cell instance $1586 m0 *1 333.26,4858.5
X$1586 \$13522 \$18 \$9995 VSS INVR01
* cell instance $1589 r180 *1 375.46,4858.5
X$1589 \$14019 \$18 \$14024 VSS INVR01
* cell instance $1594 r180 *1 411.22,4858.5
X$1594 \$18 \$13063 \$13060 VSS INVR02
* cell instance $1596 m0 *1 419.64,4858.5
X$1596 \$14026 \$18 \$13848 \$13734 \$12402 VSS NND301
* cell instance $1597 m0 *1 457.44,4858.5
X$1597 \$18 \$12402 \$14027 VSS INVR06
* cell instance $1598 m0 *1 488.22,4858.5
X$1598 \$14029 \$18 \$13065 VSS INVR05
* cell instance $1600 m0 *1 513.42,4858.5
X$1600 \$14030 \$18 \$14029 VSS INVR05
* cell instance $1604 m0 *1 553.83,4858.5
X$1604 \$13389 \$18 \$14029 VSS INVR05
* cell instance $1607 r180 *1 609.03,4858.5
X$1607 \$18 \$14032 \$11830 \$13392 VSS AND201
* cell instance $1611 m0 *1 625.01,4858.5
X$1611 \$13075 \$12866 \$18 \$13392 VSS OR2101
* cell instance $1614 r180 *1 700.3,4858.5
X$1614 \$14036 \$13852 \$14035 \$14314 \$12391 \$18 VSS AOI401
* cell instance $1615 m0 *1 700.31,4858.5
X$1615 \$18 \$14037 \$14038 VSS INVR02
* cell instance $1616 m0 *1 717.11,4858.5
X$1616 \$18 \$6860 \$14039 VSS INVR02
* cell instance $1617 m0 *1 733.91,4858.5
X$1617 \$18 \$13535 \$13074 VSS INVR02
* cell instance $1626 m0 *1 809.89,4858.5
X$1626 \$18 \$11143 \$14041 VSS INVR03
* cell instance $1630 m0 *1 839.29,4858.5
X$1630 \$18 \$14015 \$14043 VSS INVR02
* cell instance $1632 m0 *1 860.47,4858.5
X$1632 \$12276 \$18 \$14044 VSS INVR05
* cell instance $1634 m0 *1 907.71,4858.5
X$1634 \$18 \$13541 \$12268 VSS INVR03
* cell instance $1636 m0 *1 924.51,4858.5
X$1636 \$18 \$13858 \$13859 VSS INVR02
* cell instance $1637 m0 *1 941.32,4858.5
X$1637 \$18 \$13860 \$14046 VSS INVR03
* cell instance $1638 m0 *1 958.12,4858.5
X$1638 \$18 \$13859 \$14047 VSS INVR02
* cell instance $1639 m0 *1 1075.72,4858.5
X$1639 \$18 \$14050 \$13746 VSS INVR02
* cell instance $1645 m0 *1 1120.44,4858.5
X$1645 \$18 \$14317 \$13553 VSS INVR02
* cell instance $1646 m0 *1 1137.24,4858.5
X$1646 \$11349 \$18 \$14752 VSS INVR05
* cell instance $1648 m0 *1 1165.07,4858.5
X$1648 \$12421 \$13265 \$18 \$14051 VSS OR2101
* cell instance $1649 r180 *1 1198.67,4858.5
X$1649 \$14052 \$18 \$14181 VSS INVR01
* cell instance $1651 r180 *1 1217.09,4858.5
X$1651 \$14181 \$18 \$11152 VSS INVR01
* cell instance $1653 m0 *1 1217.69,4858.5
X$1653 \$18 \$14054 \$13556 VSS INVR02
* cell instance $1655 r180 *1 1356.16,4858.5
X$1655 \$18 \$14059 \$14057 VSS INVR02
* cell instance $1661 r180 *1 1416.07,4858.5
X$1661 \$18 \$13560 \$14322 \$11858 VSS AND201
* cell instance $1665 m0 *1 1430.46,4858.5
X$1665 \$18 \$13347 \$14061 \$11858 VSS AND201
* cell instance $1668 m0 *1 1467.65,4858.5
X$1668 \$18 \$14062 \$12165 VSS INVR03
* cell instance $1670 m0 *1 1484.45,4858.5
X$1670 \$18 \$13746 \$14063 VSS INVR02
* cell instance $1671 r180 *1 1531.62,4858.5
X$1671 \$18 \$14064 \$11187 VSS INVR06
* cell instance $1674 r180 *1 1567.33,4858.5
X$1674 \$14065 \$18 \$11159 VSS INVR05
* cell instance $1676 r180 *1 1600.86,4858.5
X$1676 \$18 \$13747 \$14183 VSS INVR06
* cell instance $1678 r180 *1 1620.35,4858.5
X$1678 \$18 \$14066 \$14183 VSS INVR03
* cell instance $1681 m0 *1 1637.15,4858.5
X$1681 \$18 \$4800 \$14066 VSS INVR02
* cell instance $1684 r180 *1 1687.12,4858.5
X$1684 \$18 \$13870 \$14069 VSS INVR03
* cell instance $1687 r180 *1 1720.39,4858.5
X$1687 \$18 \$13427 \$13870 VSS INVR02
* cell instance $1688 r180 *1 1737.99,4858.5
X$1688 \$18 \$14070 \$13094 VSS INVR02
* cell instance $1689 r180 *1 1754.79,4858.5
X$1689 \$18 \$14071 \$11870 VSS INVR02
* cell instance $1695 m0 *1 1882.64,4858.5
X$1695 \$18 \$14075 \$13571 VSS INVR02
* cell instance $1702 r180 *1 1966.01,4858.5
X$1702 \$18 \$14078 \$14077 VSS INVR03
* cell instance $1710 m0 *1 2008.92,4858.5
X$1710 \$18 \$13579 \$13878 VSS INVR02
* cell instance $1711 m0 *1 2026.02,4858.5
X$1711 \$18 \$14080 \$14079 VSS INVR06
* cell instance $1713 m0 *1 2063.71,4858.5
X$1713 \$18 \$13878 \$14082 VSS INVR03
* cell instance $1716 m0 *1 2097.24,4858.5
X$1716 \$13580 \$13582 \$18 \$14083 VSS OR2101
* cell instance $1717 r180 *1 2130.84,4858.5
X$1717 \$14084 \$18 \$12918 VSS INVR01
* cell instance $1719 r180 *1 2160.84,4858.5
X$1719 \$14211 \$14085 \$18 \$8942 VSS OR2101
* cell instance $1723 m0 *1 2167.42,4858.5
X$1723 \$18 \$14087 \$14082 \$13882 VSS AND201
* cell instance $1726 m0 *1 2199.32,4858.5
X$1726 \$18 \$14213 \$9116 VSS INVR06
* cell instance $1729 r180 *1 2280.13,4858.5
X$1729 \$10061 \$14214 \$13589 \$14216 \$14215 \$18 VSS AOI401
* cell instance $1732 m0 *1 2297.11,4858.5
X$1732 \$18 \$14089 \$14087 VSS INVR06
* cell instance $1734 m0 *1 2330.43,4858.5
X$1734 \$18 \$14090 \$13882 VSS INVR03
* cell instance $1741 m0 *1 2382.5,4858.5
X$1741 \$18 \$14091 \$14184 VSS INVR02
* cell instance $1743 m0 *1 2399.3,4858.5
X$1743 \$18 \$14184 \$12454 VSS INVR02
* cell instance $1744 m0 *1 2416.1,4858.5
X$1744 \$18 \$14091 \$13757 \$13882 VSS AND201
* cell instance $1748 r180 *1 2473.62,4858.5
X$1748 \$18 \$14096 \$14095 VSS INVR03
* cell instance $1752 m0 *1 2484.23,4858.5
X$1752 \$18 \$14096 \$14218 VSS INVR03
* cell instance $1753 m0 *1 2501.03,4858.5
X$1753 \$18 \$8769 \$14096 VSS INVR03
* cell instance $1759 m0 *1 2558.57,4858.5
X$1759 \$18 \$13764 \$14099 VSS INVR02
* cell instance $1760 r180 *1 2600.57,4858.5
X$1760 \$14078 \$18 \$14101 VSS INVR05
* cell instance $1761 m0 *1 2600.57,4858.5
X$1761 \$18 \$13765 \$14341 VSS INVR02
* cell instance $1767 r180 *1 2670.47,4858.5
X$1767 \$14220 \$18 \$13898 VSS INVR01
* cell instance $1785 m0 *1 2803.68,4858.5
X$1785 \$18 \$11916 \$13444 VSS INVR02
* cell instance $1789 r180 *1 2850.48,4858.5
X$1789 \$18 \$13605 \$13603 VSS INVR02
* cell instance $1793 r180 *1 2878.99,4858.5
X$1793 \$9691 \$14103 \$18 \$13126 VSS OR2101
* cell instance $1795 r180 *1 2893.68,4858.5
X$1795 \$14348 \$18 \$8212 VSS INVR01
* cell instance $1797 m0 *1 2893.68,4858.5
X$1797 \$18 \$13603 \$13118 VSS INVR02
* cell instance $1798 m0 *1 2910.48,4858.5
X$1798 \$18 \$13126 \$14104 VSS INVR06
* cell instance $1800 r180 *1 2961.5,4858.5
X$1800 \$18 \$12328 \$13898 VSS INVR02
* cell instance $1802 m0 *1 2971.51,4858.5
X$1802 \$18 \$13366 \$14509 VSS INVR03
* cell instance $1804 m0 *1 2988.31,4858.5
X$1804 \$18 \$13614 \$13765 VSS INVR02
* cell instance $1805 m0 *1 3005.11,4858.5
X$1805 \$18 \$12668 \$13615 VSS INVR03
* cell instance $1806 r180 *1 3038.71,4858.5
X$1806 \$13807 \$11906 \$13617 \$18 VSS NND201
* cell instance $1807 m0 *1 3038.71,4858.5
X$1807 \$18 \$13807 \$13764 VSS INVR03
* cell instance $1808 m0 *1 3055.51,4858.5
X$1808 \$18 \$14113 \$12328 VSS INVR03
* cell instance $1811 m0 *1 3085.51,4858.5
X$1811 \$18 \$14117 \$14118 VSS INVR03
* cell instance $1813 r180 *1 3131.71,4858.5
X$1813 \$18 \$14101 \$14120 VSS INVR06
* cell instance $1816 m0 *1 3138.83,4858.5
X$1816 \$18 \$13903 \$13452 VSS INVR03
* cell instance $1820 m0 *1 3161.71,4858.5
X$1820 \$18 \$12185 \$13903 VSS INVR02
* cell instance $1823 r180 *1 3215.98,4858.5
X$1823 \$14124 \$18 \$13142 \$14125 VSS NOR201
* cell instance $1824 m0 *1 3215.98,4858.5
X$1824 \$18 \$14126 \$14120 VSS INVR03
* cell instance $1831 r180 *1 3295.19,4858.5
X$1831 \$18 \$13906 \$13623 VSS INVR03
* cell instance $1834 m0 *1 3303.75,4858.5
X$1834 \$18 \$13621 \$9030 VSS INVR06
* cell instance $1835 r180 *1 3362.56,4858.5
X$1835 \$18 \$13137 \$12953 VSS INVR06
* cell instance $1836 r180 *1 3380.55,4858.5
X$1836 \$18 \$12952 \$13906 VSS INVR02
* cell instance $1840 m0 *1 3393.75,4858.5
X$1840 \$14186 \$12945 \$14130 \$18 VSS NND201
* cell instance $1842 m0 *1 3410.55,4858.5
X$1842 \$18 \$14186 \$13624 VSS INVR03
* cell instance $1848 m0 *1 3469.41,4858.5
X$1848 \$9937 \$14130 \$11226 \$18 VSS NND201
* cell instance $1925 m0 *1 4075.82,4858.5
X$1925 \$18 \$14133 \$7205 VSS INVR06
* cell instance $2027 m0 *1 4908.33,4858.5
X$2027 \$18 \$14135 \$14136 VSS INVR03
* cell instance $2033 m0 *1 4951.8,4858.5
X$2033 \$18 \$14137 \$12494 VSS INVR02
* cell instance $2041 m0 *1 5021.07,4858.5
X$2041 \$18 \$13913 \$13630 VSS INVR02
* cell instance $2052 m0 *1 5108.43,4858.5
X$2052 \$18 \$13646 \$14139 VSS INVR03
* cell instance $2055 m0 *1 5131.42,4858.5
X$2055 \$8743 \$13915 \$13474 \$I331412 \$13636 \$18 VSS DFCL11
* cell instance $2056 r180 *1 5278.42,4858.5
X$2056 \$10099 \$13917 \$13916 \$10268 \$13335 \$18 VSS AOI401
* cell instance $2059 m0 *1 5342.7,4858.5
X$2059 \$14144 \$18 \$12356 VSS INVR01
* cell instance $2062 r180 *1 5397.21,4858.5
X$2062 \$13642 \$18 \$13632 \$12510 VSS NOR201
* cell instance $2071 m0 *1 5451.81,4858.5
X$2071 \$18 \$14145 \$13482 VSS INVR02
* cell instance $2133 m0 *1 6026.22,4858.5
X$2133 \$18 \$14148 \$13778 VSS INVR03
* cell instance $2140 m0 *1 6080.26,4858.5
X$2140 \$14182 \$18 \$14146 \$13647 VSS NOR201
* cell instance $2144 m0 *1 6120.9,4858.5
X$2144 \$13928 \$18 \$14182 \$13927 VSS NOR201
* cell instance $2147 m0 *1 6168.33,4858.5
X$2147 \$18 \$13928 \$14236 VSS INVR03
* cell instance $2151 m0 *1 6201.95,4858.5
X$2151 \$8743 \$12776 \$14236 \$I331414 \$14150 \$18 VSS DFCL11
* cell instance $2155 m0 *1 6321.2,4858.5
X$2155 \$18 \$14150 \$14151 VSS INVR03
* cell instance $2159 m0 *1 6358.92,4858.5
X$2159 \$18 \$14151 \$14153 VSS INVR03
* cell instance $2170 m0 *1 6442.75,4858.5
X$2170 \$18 \$13187 \$14153 VSS INVR06
* cell instance $2183 m0 *1 6563.59,4858.5
X$2183 \$18 \$13175 \$13001 \$14157 VSS AND201
* cell instance $2185 m0 *1 6588.79,4858.5
X$2185 \$13917 \$18 \$14158 VSS INVR05
* cell instance $2186 m0 *1 6613.99,4858.5
X$2186 \$18 \$14160 \$14367 VSS INVR03
* cell instance $2189 m0 *1 6637.1,4858.5
X$2189 \$8743 \$12777 \$14161 \$I331430 \$13931 \$18 VSS DFCL11
* cell instance $2193 m0 *1 6753.51,4858.5
X$2193 \$18 \$13931 \$14162 VSS INVR03
* cell instance $2198 m0 *1 6782.25,4858.5
X$2198 \$18 \$13784 \$14162 VSS INVR06
* cell instance $2200 r180 *1 6833.07,4858.5
X$2200 \$18 \$13652 \$14161 VSS INVR03
* cell instance $2204 m0 *1 6848.15,4858.5
X$2204 \$18 \$13778 \$13656 VSS INVR02
* cell instance $2216 m0 *1 6945.66,4858.5
X$2216 \$18 \$12378 \$13184 VSS INVR06
* cell instance $2221 r180 *1 7131.06,4858.5
X$2221 \$14168 \$13784 \$13004 \$14167 \$18 VSS DEC24H
* cell instance $2223 m0 *1 7131.06,4858.5
X$2223 \$18 \$14167 \$14170 VSS INVR02
* cell instance $2241 m0 *1 7279.21,4858.5
X$2241 \$18 \$13784 \$14171 VSS INVR03
* cell instance $2245 m0 *1 7313.97,4858.5
X$2245 \$14172 \$18 \$14171 VSS INVR05
* cell instance $2319 m0 *1 7911.76,4858.5
X$2319 \$11780 \$18 \$14173 VSS INVR05
* cell instance $2320 m0 *1 7936.96,4858.5
X$2320 \$18 \$14173 \$11303 VSS INVR06
* cell instance $2339 m0 *1 8106.68,4858.5
X$2339 \$18 \$14172 \$13665 VSS INVR03
* cell instance $2430 m0 *1 8838.71,4858.5
X$2430 \$18 \$14175 \$13937 VSS INVR02
* cell instance $2438 r180 *1 44.49,5035.9
X$2438 \$18 \$7474 \$14009 VSS INVR02
* cell instance $2453 m0 *1 234.16,5035.9
X$2453 \$18 \$15025 \$14577 VSS INVR06
* cell instance $2454 m0 *1 263.56,5035.9
X$2454 \$18 \$14745 \$11818 VSS INVR03
* cell instance $2457 m0 *1 294.18,5035.9
X$2457 \$18 \$15027 \$15175 VSS INVR03
* cell instance $2459 m0 *1 310.98,5035.9
X$2459 \$12857 \$18 \$15175 VSS INVR05
* cell instance $2461 r180 *1 355.66,5035.9
X$2461 \$18 \$15029 \$14896 VSS INVR02
* cell instance $2462 m0 *1 355.66,5035.9
X$2462 \$18 \$14896 \$14897 VSS INVR02
* cell instance $2464 m0 *1 382.09,5035.9
X$2464 \$18 \$14742 \$14898 VSS INVR02
* cell instance $2466 r180 *1 411.49,5035.9
X$2466 \$15030 \$18 \$14898 VSS INVR01
* cell instance $2467 m0 *1 411.49,5035.9
X$2467 \$18 \$14898 \$13850 VSS INVR02
* cell instance $2469 r180 *1 458.28,5035.9
X$2469 \$13848 \$15474 \$18 \$15032 VSS OR2101
* cell instance $2470 m0 *1 458.28,5035.9
X$2470 \$18 \$15034 \$15033 VSS INVR06
* cell instance $2471 r180 *1 510.23,5035.9
X$2471 \$14587 \$15035 \$18 \$11136 VSS OR2101
* cell instance $2476 m0 *1 526,5035.9
X$2476 \$14456 \$18 \$11136 VSS INVR05
* cell instance $2478 r180 *1 572.21,5035.9
X$2478 \$15041 \$15039 \$18 \$15040 VSS OR2101
* cell instance $2480 m0 *1 580.53,5035.9
X$2480 \$18 \$14897 \$15042 VSS INVR02
* cell instance $2481 m0 *1 597.9,5035.9
X$2481 \$18 \$15043 \$15044 VSS INVR02
* cell instance $2486 m0 *1 647.83,5035.9
X$2486 \$18 \$14457 \$14742 VSS INVR02
* cell instance $2490 m0 *1 677.5,5035.9
X$2490 \$18 \$14746 \$14901 \$15046 VSS AND201
* cell instance $2491 m0 *1 702.7,5035.9
X$2491 \$15184 \$18 \$13536 VSS INVR01
* cell instance $2492 m0 *1 715.3,5035.9
X$2492 \$14901 \$18 \$15184 VSS INVR01
* cell instance $2493 m0 *1 727.9,5035.9
X$2493 \$18 \$14038 \$14314 VSS INVR02
* cell instance $2495 m0 *1 748.89,5035.9
X$2495 \$14902 \$18 \$15232 VSS INVR01
* cell instance $2497 r180 *1 783.07,5035.9
X$2497 \$14747 \$18 \$15232 VSS INVR01
* cell instance $2498 m0 *1 783.44,5035.9
X$2498 \$14904 \$18 \$14746 \$14902 VSS NOR201
* cell instance $2501 m0 *1 822.87,5035.9
X$2501 \$18 \$15493 \$14751 VSS INVR06
* cell instance $2502 m0 *1 852.27,5035.9
X$2502 \$14747 \$15050 \$18 \$15046 VSS OR2101
* cell instance $2503 m0 *1 873.27,5035.9
X$2503 \$18 \$15235 \$15051 VSS INVR02
* cell instance $2504 m0 *1 890.07,5035.9
X$2504 \$18 \$14904 \$14745 VSS INVR03
* cell instance $2507 r180 *1 940.47,5035.9
X$2507 \$18 \$14464 \$14906 VSS INVR02
* cell instance $2511 m0 *1 960.2,5035.9
X$2511 \$18 \$14596 \$15053 VSS INVR02
* cell instance $2514 m0 *1 981.19,5035.9
X$2514 \$18 \$14750 \$14049 VSS INVR03
* cell instance $2515 m0 *1 997.99,5035.9
X$2515 \$18 \$15053 \$14908 VSS INVR02
* cell instance $2518 m0 *1 1025.49,5035.9
X$2518 \$18 \$14908 \$14469 VSS INVR02
* cell instance $2522 m0 *1 1063.35,5035.9
X$2522 \$15058 \$18 \$14462 VSS INVR05
* cell instance $2524 m0 *1 1088.55,5035.9
X$2524 \$18 \$14469 \$15059 VSS INVR03
* cell instance $2525 m0 *1 1105.35,5035.9
X$2525 \$18 \$13409 \$15058 VSS INVR06
* cell instance $2528 m0 *1 1142.51,5035.9
X$2528 \$18 \$15061 \$15062 VSS INVR03
* cell instance $2534 m0 *1 1186.38,5035.9
X$2534 \$18 \$13865 \$14752 VSS INVR03
* cell instance $2539 m0 *1 1227.8,5035.9
X$2539 \$14602 \$14912 \$18 \$12421 VSS OR2101
* cell instance $2540 m0 *1 1248.8,5035.9
X$2540 \$14751 \$18 \$15064 VSS INVR05
* cell instance $2541 r180 *1 1290.8,5035.9
X$2541 \$14059 \$14915 \$14912 \$18 VSS NND201
* cell instance $2550 m0 *1 1355.66,5035.9
X$2550 \$18 \$15065 \$12421 VSS INVR03
* cell instance $2551 r180 *1 1389.26,5035.9
X$2551 \$14915 \$12814 \$12421 \$18 VSS NND201
* cell instance $2564 m0 *1 1486.55,5035.9
X$2564 \$18 \$13564 \$14062 VSS INVR02
* cell instance $2568 m0 *1 1520.72,5035.9
X$2568 \$18 \$15068 \$14750 VSS INVR03
* cell instance $2570 m0 *1 1537.52,5035.9
X$2570 \$18 \$14918 \$15070 VSS INVR02
* cell instance $2572 r180 *1 1578.88,5035.9
X$2572 \$15071 \$14918 \$18 \$14478 VSS OR2101
* cell instance $2576 r180 *1 1609.69,5035.9
X$2576 \$18 \$15071 \$13569 \$14479 VSS AND201
* cell instance $2583 m0 *1 1654.25,5035.9
X$2583 \$18 \$13571 \$13571 VSS INVR02
* cell instance $2587 m0 *1 1686.19,5035.9
X$2587 \$18 \$15074 \$15075 VSS INVR02
* cell instance $2595 m0 *1 1738.94,5035.9
X$2595 \$18 \$13572 \$14071 VSS INVR02
* cell instance $2602 m0 *1 1801.69,5035.9
X$2602 \$18 \$15077 \$15373 VSS INVR03
* cell instance $2608 m0 *1 1851.54,5035.9
X$2608 \$18 \$14919 \$15079 VSS INVR03
* cell instance $2616 m0 *1 1958.89,5035.9
X$2616 \$14920 \$18 \$15082 VSS INVR05
* cell instance $2619 m0 *1 1986.2,5035.9
X$2619 \$18 \$14079 \$8994 VSS INVR06
* cell instance $2620 r180 *1 2036.6,5035.9
X$2620 \$12461 \$15084 \$18 \$14079 VSS OR2101
* cell instance $2621 m0 *1 2036.6,5035.9
X$2621 \$15087 \$18 \$15085 VSS INVR05
* cell instance $2622 r180 *1 2095.4,5035.9
X$2622 \$14080 \$18 \$14765 \$14762 \$14761 VSS AND301
* cell instance $2625 m0 *1 2102.38,5035.9
X$2625 \$18 \$14080 \$14627 VSS INVR02
* cell instance $2630 m0 *1 2134.49,5035.9
X$2630 \$18 \$14631 \$15087 VSS INVR06
* cell instance $2631 m0 *1 2165.36,5035.9
X$2631 \$18 \$14211 \$15005 \$10048 VSS AND201
* cell instance $2635 r180 *1 2222.85,5035.9
X$2635 \$10048 \$14762 \$18 \$14213 VSS OR2101
* cell instance $2637 r180 *1 2239.65,5035.9
X$2637 \$18 \$15097 \$15005 VSS INVR02
* cell instance $2643 m0 *1 2274.46,5035.9
X$2643 \$18 \$14215 \$13435 \$11916 VSS AND201
* cell instance $2649 m0 *1 2335.87,5035.9
X$2649 \$18 \$14637 \$13435 \$11916 VSS AND201
* cell instance $2650 m0 *1 2361.07,5035.9
X$2650 \$18 \$11916 \$14926 VSS INVR02
* cell instance $2652 m0 *1 2386.28,5035.9
X$2652 \$18 \$15101 \$15102 VSS INVR02
* cell instance $2653 m0 *1 2403.08,5035.9
X$2653 \$15104 \$18 \$14774 VSS INVR05
* cell instance $2656 m0 *1 2435.63,5035.9
X$2656 \$18 \$14926 \$15105 VSS INVR03
* cell instance $2660 m0 *1 2469.23,5035.9
X$2660 \$18 \$14774 \$15257 VSS INVR03
* cell instance $2661 m0 *1 2486.03,5035.9
X$2661 \$18 \$14774 \$15105 VSS INVR06
* cell instance $2665 r180 *1 2548.06,5035.9
X$2665 \$13275 \$14929 \$15541 \$18 VSS NND201
* cell instance $2668 m0 *1 2550.3,5035.9
X$2668 \$18 \$15259 \$14643 VSS INVR04
* cell instance $2671 r180 *1 2602.07,5035.9
X$2671 \$18 \$15112 \$11192 VSS INVR03
* cell instance $2678 r180 *1 2664.78,5035.9
X$2678 \$14090 \$18 \$15261 VSS INVR05
* cell instance $2681 m0 *1 2668.71,5035.9
X$2681 \$18 \$15263 \$14765 VSS INVR03
* cell instance $2683 r180 *1 2702.31,5035.9
X$2683 \$18 \$12935 \$15265 VSS INVR03
* cell instance $2686 m0 *1 2709.37,5035.9
X$2686 \$18 \$15554 \$14080 VSS INVR03
* cell instance $2689 r180 *1 2756.49,5035.9
X$2689 \$18 \$14781 \$15117 VSS INVR04
* cell instance $2694 r180 *1 2796.16,5035.9
X$2694 \$18 \$15117 \$14936 \$14104 VSS AND201
* cell instance $2695 m0 *1 2797.58,5035.9
X$2695 \$18 \$15120 \$15121 VSS INVR03
* cell instance $2698 r180 *1 2839.59,5035.9
X$2698 \$18 \$11916 \$14845 VSS INVR02
* cell instance $2703 r180 *1 2880.51,5035.9
X$2703 \$18 \$15123 \$15124 \$14507 VSS AND201
* cell instance $2706 m0 *1 2891.6,5035.9
X$2706 \$18 \$13448 \$14936 \$14647 VSS AND201
* cell instance $2710 r180 *1 2946.98,5035.9
X$2710 \$18 \$15126 \$15125 VSS INVR03
* cell instance $2712 m0 *1 3002.19,5035.9
X$2712 \$18 \$15268 \$12668 \$15128 \$13593 VSS ORND01
* cell instance $2713 m0 *1 3031.59,5035.9
X$2713 \$18 \$14944 \$15130 VSS INVR02
* cell instance $2714 m0 *1 3048.39,5035.9
X$2714 \$18 \$15128 \$15130 VSS INVR06
* cell instance $2715 r180 *1 3107.19,5035.9
X$2715 \$18 \$14512 \$12945 VSS INVR06
* cell instance $2717 r180 *1 3126.57,5035.9
X$2717 \$18 \$14653 \$14944 VSS INVR02
* cell instance $2718 m0 *1 3126.57,5035.9
X$2718 \$14118 \$15134 \$18 \$11226 VSS OR2101
* cell instance $2719 r180 *1 3185.37,5035.9
X$2719 \$14517 \$14656 \$15134 \$14662 \$14118 \$18 VSS AND401
* cell instance $2722 r180 *1 3231.44,5035.9
X$2722 \$18 \$15136 \$15137 VSS INVR06
* cell instance $2726 m0 *1 3252.39,5035.9
X$2726 \$15138 \$18 \$13621 \$10074 VSS NOR201
* cell instance $2732 r180 *1 3332.79,5035.9
X$2732 \$18 \$14663 \$15139 VSS INVR02
* cell instance $2733 m0 *1 3332.79,5035.9
X$2733 \$18 \$13618 \$14522 VSS INVR03
* cell instance $2738 m0 *1 3373.04,5035.9
X$2738 \$18 \$15142 \$14788 VSS INVR02
* cell instance $2740 m0 *1 3389.84,5035.9
X$2740 \$11931 \$18 \$10630 VSS INVR05
* cell instance $2741 m0 *1 3415.04,5035.9
X$2741 \$18 \$14788 \$14954 VSS INVR02
* cell instance $2742 m0 *1 3431.84,5035.9
X$2742 \$14958 \$14523 \$15142 \$18 VSS NND201
* cell instance $2743 r180 *1 3465.44,5035.9
X$2743 \$18 \$13626 \$15275 VSS INVR02
* cell instance $2744 m0 *1 3465.44,5035.9
X$2744 \$15146 \$18 \$14523 \$15137 VSS NOR201
* cell instance $2840 m0 *1 4259.07,5035.9
X$2840 \$18 \$14790 \$14668 VSS INVR03
* cell instance $2882 m0 *1 4600.48,5035.9
X$2882 \$18 \$14532 \$15148 VSS INVR03
* cell instance $2909 m0 *1 4825.8,5035.9
X$2909 \$18 \$12344 \$15195 VSS INVR02
* cell instance $2910 m0 *1 4842.6,5035.9
X$2910 \$18 \$15195 \$14790 VSS INVR03
* cell instance $2917 m0 *1 4904.13,5035.9
X$2917 \$18 \$15150 \$14136 VSS INVR06
* cell instance $2961 m0 *1 5275.22,5035.9
X$2961 \$18 \$13291 \$15151 VSS INVR02
* cell instance $2963 m0 *1 5292.02,5035.9
X$2963 \$15152 \$18 \$15151 VSS INVR05
* cell instance $3101 m0 *1 6414.5,5035.9
X$3101 \$18 \$14677 \$15153 VSS INVR02
* cell instance $3106 r180 *1 6547.57,5035.9
X$3106 \$8743 \$14962 \$15155 \$I331388 \$15154 \$18 VSS DFCL11
* cell instance $3119 r180 *1 6643.02,5035.9
X$3119 \$18 \$15157 \$15155 VSS INVR03
* cell instance $3120 m0 *1 6643.45,5035.9
X$3120 \$18 \$15159 \$14554 \$14157 VSS AND201
* cell instance $3121 m0 *1 6668.65,5035.9
X$3121 \$18 \$15160 \$14554 VSS INVR03
* cell instance $3123 r180 *1 6711.77,5035.9
X$3123 \$18 \$14553 \$15161 VSS INVR02
* cell instance $3130 m0 *1 6743.69,5035.9
X$3130 \$18 \$15163 \$15164 VSS INVR03
* cell instance $3132 r180 *1 6777.29,5035.9
X$3132 \$18 \$15183 \$14368 VSS INVR03
* cell instance $3135 r180 *1 6817.13,5035.9
X$3135 \$15183 \$18 \$14792 \$15166 VSS NOR201
* cell instance $3138 m0 *1 6823.65,5035.9
X$3138 \$18 \$13653 \$13784 \$13651 VSS AND201
* cell instance $3141 r180 *1 6880.71,5035.9
X$3141 \$18 \$15167 \$15168 \$14967 VSS AND201
* cell instance $3144 r180 *1 6932.11,5035.9
X$3144 \$14967 \$15170 \$15169 \$18 VSS XNR201
* cell instance $3146 r180 *1 6957.32,5035.9
X$3146 \$18 \$14792 \$13657 \$15169 VSS AND201
* cell instance $3149 m0 *1 6973.48,5035.9
X$3149 \$18 \$14559 \$15170 VSS INVR06
* cell instance $3376 m0 *1 8800.84,5035.9
X$3376 \$18 \$15173 \$14689 VSS INVR02
* cell instance $3388 m90 *1 45.04,4721.1
X$3388 \$18 \$12384 \$13512 VSS INVR02
* cell instance $3404 r0 *1 196.34,4721.1
X$3404 \$18 \$13518 \$14012 \$13516 VSS AND201
* cell instance $3405 r0 *1 221.55,4721.1
X$3405 \$18 \$5110 \$13379 VSS INVR06
* cell instance $3408 r0 *1 261.81,4721.1
X$3408 \$18 \$13839 \$13382 VSS INVR02
* cell instance $3411 r0 *1 291.81,4721.1
X$3411 \$13514 \$18 \$13382 VSS INVR05
* cell instance $3415 r0 *1 322.76,4721.1
X$3415 \$13066 \$18 \$11827 \$13522 VSS NOR201
* cell instance $3416 r0 *1 356.36,4721.1
X$3416 \$18 \$13056 \$12390 \$13310 VSS AND201
* cell instance $3417 m90 *1 398.37,4721.1
X$3417 \$13516 \$12871 \$12858 \$18 VSS NND201
* cell instance $3420 r0 *1 409.11,4721.1
X$3420 \$18 \$13060 \$12396 VSS INVR02
* cell instance $3422 m90 *1 453.83,4721.1
X$3422 \$18 \$13734 \$13850 \$8918 VSS AND201
* cell instance $3424 r0 *1 455.29,4721.1
X$3424 \$18 \$9425 \$13062 VSS INVR06
* cell instance $3425 m90 *1 497.3,4721.1
X$3425 \$13310 \$18 \$12417 VSS INVR01
* cell instance $3426 r0 *1 497.9,4721.1
X$3426 \$18 \$8918 \$12148 VSS INVR02
* cell instance $3429 m90 *1 556.07,4721.1
X$3429 \$9422 \$18 \$13389 VSS INVR05
* cell instance $3430 r0 *1 556.07,4721.1
X$3430 \$18 \$13532 \$13069 VSS INVR03
* cell instance $3431 r0 *1 572.87,4721.1
X$3431 \$18 \$12417 \$13392 VSS INVR03
* cell instance $3433 m90 *1 619.67,4721.1
X$3433 \$12268 \$12876 \$18 \$12871 VSS OR2101
* cell instance $3442 r0 *1 667.07,4721.1
X$3442 \$13534 \$18 \$13319 VSS INVR01
* cell instance $3447 r0 *1 687.57,4721.1
X$3447 \$18 \$13077 \$13535 VSS INVR02
* cell instance $3448 r0 *1 704.8,4721.1
X$3448 \$13319 \$18 \$13536 VSS INVR01
* cell instance $3449 r0 *1 719.42,4721.1
X$3449 \$13541 \$18 \$11830 \$13539 \$13534 VSS NND301
* cell instance $3451 r0 *1 757.22,4721.1
X$3451 \$12267 \$13329 \$18 \$12402 VSS OR2101
* cell instance $3454 r0 *1 791.42,4721.1
X$3454 \$18 \$12276 \$13327 VSS INVR03
* cell instance $3457 r0 *1 817.22,4721.1
X$3457 \$12419 \$12887 \$18 \$12880 VSS OR2101
* cell instance $3459 r0 *1 859.22,4721.1
X$3459 \$18 \$11829 \$11841 VSS INVR04
* cell instance $3460 r0 *1 881.49,4721.1
X$3460 \$18 \$13063 \$13326 VSS INVR02
* cell instance $3462 r0 *1 898.29,4721.1
X$3462 \$12886 \$18 \$11848 VSS INVR05
* cell instance $3463 r0 *1 923.49,4721.1
X$3463 \$18 \$11143 \$13327 VSS INVR06
* cell instance $3466 m90 *1 980.5,4721.1
X$3466 \$12882 \$13329 \$12270 \$18 VSS NND201
* cell instance $3479 r0 *1 1073.84,4721.1
X$3479 \$13549 \$18 \$13409 VSS INVR05
* cell instance $3483 m90 *1 1127.13,4721.1
X$3483 \$13411 \$13411 \$18 \$12893 VSS OR2101
* cell instance $3486 r0 *1 1132.89,4721.1
X$3486 \$18 \$13411 \$13088 VSS INVR02
* cell instance $3494 r0 *1 1188.96,4721.1
X$3494 \$18 \$13553 \$13412 VSS INVR03
* cell instance $3497 m90 *1 1242.13,4721.1
X$3497 \$13411 \$13415 \$13265 \$18 VSS NND201
* cell instance $3500 r0 *1 1255.33,4721.1
X$3500 \$18 \$13556 \$13865 VSS INVR03
* cell instance $3502 r0 *1 1273.88,4721.1
X$3502 \$18 \$13557 \$13559 VSS INVR02
* cell instance $3504 r0 *1 1290.68,4721.1
X$3504 \$18 \$13559 \$13416 VSS INVR03
* cell instance $3510 r0 *1 1345.27,4721.1
X$3510 \$18 \$13416 \$13418 VSS INVR03
* cell instance $3513 m90 *1 1392.08,4721.1
X$3513 \$13268 \$13091 \$18 \$13560 VSS OR2101
* cell instance $3515 r0 *1 1396.05,4721.1
X$3515 \$18 \$13269 \$13419 VSS INVR03
* cell instance $3520 m90 *1 1445.63,4721.1
X$3520 \$13268 \$18 \$13562 VSS INVR01
* cell instance $3527 m90 *1 1505.36,4721.1
X$3527 \$12903 \$13564 \$18 \$13347 VSS OR2101
* cell instance $3530 m90 *1 1533.61,4721.1
X$3530 \$18 \$12905 \$13562 VSS INVR02
* cell instance $3533 m90 *1 1572.76,4721.1
X$3533 \$18 \$11858 \$11159 VSS INVR06
* cell instance $3537 r0 *1 1585.97,4721.1
X$3537 \$18 \$4800 \$13700 VSS INVR02
* cell instance $3541 r0 *1 1658.76,4721.1
X$3541 \$13095 \$13569 \$13570 \$13571 \$13572 \$18 VSS AND401
* cell instance $3555 m90 *1 2058,4721.1
X$3555 \$18 \$13579 \$13580 \$11888 VSS AND201
* cell instance $3562 r0 *1 2106.06,4721.1
X$3562 \$12916 \$18 \$13752 \$12471 \$13753 VSS AND301
* cell instance $3564 m90 *1 2169.25,4721.1
X$3564 \$18 \$13753 \$13582 \$11878 VSS AND201
* cell instance $3567 m90 *1 2202.1,4721.1
X$3567 \$18 \$11885 \$13580 VSS INVR02
* cell instance $3570 r0 *1 2208.72,4721.1
X$3570 \$13584 \$18 \$11180 VSS INVR05
* cell instance $3574 m90 *1 2265.34,4721.1
X$3574 \$18 \$13586 \$12921 VSS INVR02
* cell instance $3575 m90 *1 2282.15,4721.1
X$3575 \$18 \$12921 \$13587 VSS INVR02
* cell instance $3578 r0 *1 2292.66,4721.1
X$3578 \$6832 \$18 \$13589 VSS INVR05
* cell instance $3586 m90 *1 2420.22,4721.1
X$3586 \$13592 \$10620 \$13586 \$11889 \$13757 \$18 VSS AOI401
* cell instance $3588 r0 *1 2425.03,4721.1
X$3588 \$12921 \$18 \$13435 VSS INVR05
* cell instance $3591 r0 *1 2461.2,4721.1
X$3591 \$18 \$13593 \$13111 VSS INVR03
* cell instance $3596 r0 *1 2493.12,4721.1
X$3596 \$18 \$13378 \$11885 VSS INVR06
* cell instance $3603 r0 *1 2564.86,4721.1
X$3603 \$18 \$13287 \$13763 VSS INVR02
* cell instance $3607 m90 *1 2617.96,4721.1
X$3607 \$12835 \$13096 \$18 \$13440 VSS OR2101
* cell instance $3614 r0 *1 2659.05,4721.1
X$3614 \$14343 \$18 \$12318 VSS INVR05
* cell instance $3616 m90 *1 2701.05,4721.1
X$3616 \$18 \$10630 \$13592 VSS INVR02
* cell instance $3624 m90 *1 2771.87,4721.1
X$3624 \$18 \$13598 \$13599 \$11903 VSS AND201
* cell instance $3625 r0 *1 2772.48,4721.1
X$3625 \$18 \$13366 \$13444 VSS INVR06
* cell instance $3627 r0 *1 2805.13,4721.1
X$3627 \$18 \$11923 \$12324 VSS INVR03
* cell instance $3629 m90 *1 2838.73,4721.1
X$3629 \$18 \$11906 \$13119 VSS INVR02
* cell instance $3630 m90 *1 2859.73,4721.1
X$3630 \$13446 \$13599 \$18 \$13602 VSS OR2101
* cell instance $3632 m90 *1 2874.53,4721.1
X$3632 \$13602 \$18 \$13603 VSS INVR01
* cell instance $3636 m90 *1 2911.42,4721.1
X$3636 \$13133 \$13605 \$18 \$13366 VSS OR2101
* cell instance $3639 r0 *1 2919.67,4721.1
X$3639 \$12835 \$18 \$10635 \$13607 \$13608 VSS NND301
* cell instance $3640 m90 *1 2991.07,4721.1
X$3640 \$13608 \$18 \$13598 \$13611 \$13610 VSS AND301
* cell instance $3641 r0 *1 2991.07,4721.1
X$3641 \$13613 \$13614 \$18 \$13448 VSS OR2101
* cell instance $3645 r0 *1 3032.59,4721.1
X$3645 \$18 \$13615 \$13449 VSS INVR03
* cell instance $3646 r0 *1 3049.39,4721.1
X$3646 \$18 \$13616 \$13136 VSS INVR06
* cell instance $3648 m90 *1 3104.2,4721.1
X$3648 \$13452 \$13617 \$18 \$11226 VSS OR2101
* cell instance $3650 r0 *1 3107.47,4721.1
X$3650 \$18 \$12943 \$13287 VSS INVR03
* cell instance $3652 r0 *1 3124.27,4721.1
X$3652 \$18 \$13353 \$13618 VSS INVR02
* cell instance $3655 r0 *1 3152.51,4721.1
X$3655 \$18 \$13353 \$13350 \$13619 VSS AND201
* cell instance $3662 r0 *1 3214.23,4721.1
X$3662 \$13619 \$18 \$13131 VSS INVR01
* cell instance $3663 r0 *1 3226.83,4721.1
X$3663 \$18 \$12948 \$13350 VSS INVR02
* cell instance $3666 m90 *1 3317.47,4721.1
X$3666 \$13621 \$13623 \$13349 \$18 VSS PDDR04
* cell instance $3667 m90 *1 3338.48,4721.1
X$3667 \$13349 \$12949 \$18 \$12485 VSS OR2101
* cell instance $3669 r0 *1 3347.48,4721.1
X$3669 \$18 \$12488 \$11741 VSS INVR03
* cell instance $3674 m90 *1 3396.85,4721.1
X$3674 \$18 \$13624 \$11928 VSS INVR03
* cell instance $3680 m90 *1 3440.04,4721.1
X$3680 \$18 \$13625 \$13133 VSS INVR03
* cell instance $3682 m90 *1 3465.89,4721.1
X$3682 \$18 \$13626 \$13625 VSS INVR02
* cell instance $3759 m90 *1 4093.13,4721.1
X$3759 \$18 \$13627 \$6920 VSS INVR06
* cell instance $3859 r0 *1 4874.04,4721.1
X$3859 \$8743 \$12963 \$13148 \$I331334 \$14137 \$18 VSS DFCL11
* cell instance $3872 r0 *1 5068.18,4721.1
X$3872 \$18 \$12499 \$12501 VSS INVR02
* cell instance $3875 r0 *1 5093.02,4721.1
X$3875 \$18 \$13150 \$13471 VSS INVR03
* cell instance $3878 r0 *1 5116.46,4721.1
X$3878 \$18 \$13631 \$13632 VSS INVR02
* cell instance $3881 r0 *1 5139.83,4721.1
X$3881 \$18 \$13340 \$13473 VSS INVR03
* cell instance $3884 r0 *1 5174.13,4721.1
X$3884 \$18 \$13630 \$13474 VSS INVR03
* cell instance $3887 r0 *1 5199.61,4721.1
X$3887 \$18 \$13634 \$13340 VSS INVR03
* cell instance $3893 r0 *1 5253.93,4721.1
X$3893 \$18 \$13636 \$13476 VSS INVR03
* cell instance $3898 m90 *1 5335.59,4721.1
X$3898 \$10667 \$11271 \$12974 \$10268 \$13335 \$18 VSS AOI401
* cell instance $3899 r0 *1 5335.59,4721.1
X$3899 \$18 \$12975 \$12977 VSS INVR02
* cell instance $3905 r0 *1 5384.4,4721.1
X$3905 \$18 \$13642 \$12514 VSS INVR03
* cell instance $3910 r0 *1 5413.21,4721.1
X$3910 \$13291 \$18 \$13482 VSS INVR05
* cell instance $3918 r0 *1 5491.72,4721.1
X$3918 \$18 \$10269 \$13335 VSS INVR02
* cell instance $3987 m90 *1 6061.92,4721.1
X$3987 \$18 \$13644 \$12524 VSS INVR02
* cell instance $3991 m90 *1 6096.64,4721.1
X$3991 \$18 \$13162 \$13644 VSS INVR02
* cell instance $3995 r0 *1 6115.99,4721.1
X$3995 \$18 \$13927 \$13647 \$13646 VSS AND201
* cell instance $3998 r0 *1 6143.45,4721.1
X$3998 \$18 \$13159 \$12774 VSS INVR03
* cell instance $4000 r0 *1 6164.45,4721.1
X$4000 \$18 \$13646 \$13649 VSS INVR02
* cell instance $4004 r0 *1 6201.43,4721.1
X$4004 \$18 \$12774 \$13702 VSS INVR03
* cell instance $4007 r0 *1 6224.53,4721.1
X$4007 \$18 \$12776 \$13702 VSS INVR06
* cell instance $4012 r0 *1 6286.45,4721.1
X$4012 \$18 \$11980 \$11427 VSS INVR03
* cell instance $4032 r0 *1 6455.4,4721.1
X$4032 \$18 \$13489 \$12986 VSS INVR02
* cell instance $4033 m90 *1 6573,4721.1
X$4033 \$8743 \$12776 \$13171 \$I331492 \$13489 \$18 VSS DFCL11
* cell instance $4043 r0 *1 6635.27,4721.1
X$4043 \$12777 \$18 \$12537 VSS INVR05
* cell instance $4046 r0 *1 6677.7,4721.1
X$4046 \$18 \$12539 \$13493 VSS INVR03
* cell instance $4051 r0 *1 6709.84,4721.1
X$4051 \$18 \$13493 \$12542 VSS INVR03
* cell instance $4054 r0 *1 6735.05,4721.1
X$4054 \$18 \$13180 \$12538 VSS INVR02
* cell instance $4058 r0 *1 6766.26,4721.1
X$4058 \$18 \$13182 \$12542 \$13651 VSS AND201
* cell instance $4060 m90 *1 6829.47,4721.1
X$4060 \$13652 \$18 \$13654 \$13653 VSS NOR201
* cell instance $4061 m90 *1 6846.27,4721.1
X$4061 \$18 \$12994 \$12540 VSS INVR02
* cell instance $4065 r0 *1 6867,4721.1
X$4065 \$18 \$13656 \$12997 VSS INVR03
* cell instance $4066 r0 *1 6883.8,4721.1
X$4066 \$13657 \$18 \$12997 VSS INVR05
* cell instance $4070 m90 *1 6967.96,4721.1
X$4070 \$13000 \$13003 \$12995 \$18 VSS XNR201
* cell instance $4075 m90 *1 7014.53,4721.1
X$4075 \$13000 \$13660 \$18 \$13297 VSS OR2101
* cell instance $4079 r0 *1 7026.6,4721.1
X$4079 \$18 \$13003 \$13663 VSS INVR02
* cell instance $4083 r0 *1 7054.43,4721.1
X$4083 \$18 \$13297 \$13003 VSS INVR06
* cell instance $4088 m90 *1 7129.93,4721.1
X$4088 \$18 \$13501 \$12546 VSS INVR02
* cell instance $4094 m90 *1 7187.33,4721.1
X$4094 \$18 \$13501 \$12377 \$12378 VSS AND201
* cell instance $4129 r0 *1 7456.11,4721.1
X$4129 \$12377 \$18 \$12548 VSS INVR05
* cell instance $4164 r0 *1 7740.41,4721.1
X$4164 \$18 \$13298 \$13297 VSS INVR06
* cell instance $4271 r0 *1 8614.2,4721.1
X$4271 \$18 \$13189 \$12695 VSS INVR03
* cell instance $4302 r0 *1 8865.46,4721.1
X$4302 \$18 \$13665 \$13666 VSS INVR02
* cell instance $4304 m90 *1 49.34,5075.9
X$4304 \$18 \$7474 \$13836 VSS INVR02
* cell instance $4307 r0 *1 67.2,5075.9
X$4307 \$18 \$15612 \$14441 VSS INVR03
* cell instance $4318 r0 *1 302.48,5075.9
X$4318 \$18 \$15354 \$14027 VSS INVR03
* cell instance $4320 r0 *1 319.28,5075.9
X$4320 \$15618 \$18 \$15473 VSS INVR01
* cell instance $4324 r0 *1 346.2,5075.9
X$4324 \$14445 \$15354 \$9996 \$18 VSS NND201
* cell instance $4325 m90 *1 379.81,5075.9
X$4325 \$15029 \$14582 \$15030 \$18 VSS NND201
* cell instance $4329 m90 *1 422.32,5075.9
X$4329 \$18 \$15621 \$12395 \$15035 VSS AND201
* cell instance $4330 m90 *1 443.32,5075.9
X$4330 \$15475 \$15617 \$18 \$15474 VSS OR2101
* cell instance $4334 m90 *1 475.74,5075.9
X$4334 \$18 \$9425 \$15475 VSS INVR03
* cell instance $4338 r0 *1 487.49,5075.9
X$4338 \$18 \$15480 \$15478 VSS INVR03
* cell instance $4340 r0 *1 504.29,5075.9
X$4340 \$18 \$15039 \$15480 VSS INVR02
* cell instance $4341 r0 *1 521.09,5075.9
X$4341 \$18 \$13848 \$15481 VSS INVR06
* cell instance $4344 r0 *1 563.93,5075.9
X$4344 \$15478 \$15043 \$18 \$9425 VSS OR2101
* cell instance $4346 m90 *1 618.53,5075.9
X$4346 \$15624 \$18 \$15626 \$13848 VSS NOR201
* cell instance $4348 r0 *1 623.35,5075.9
X$4348 \$15627 \$18 \$14587 \$15487 VSS NOR201
* cell instance $4349 m90 *1 677.95,5075.9
X$4349 \$14456 \$15487 \$18 \$13392 VSS OR2101
* cell instance $4351 r0 *1 683.08,5075.9
X$4351 \$18 \$15044 \$15046 VSS INVR02
* cell instance $4353 r0 *1 699.88,5075.9
X$4353 \$18 \$13536 \$15628 VSS INVR02
* cell instance $4354 r0 *1 716.68,5075.9
X$4354 \$18 \$15629 \$13536 VSS INVR03
* cell instance $4355 r0 *1 733.48,5075.9
X$4355 \$18 \$15630 \$15489 VSS INVR06
* cell instance $4356 r0 *1 762.88,5075.9
X$4356 \$18 \$15631 \$14463 VSS INVR02
* cell instance $4359 r0 *1 792.28,5075.9
X$4359 \$15805 \$15235 \$18 \$15491 VSS OR2101
* cell instance $4360 m90 *1 830.08,5075.9
X$4360 \$18 \$14464 \$15633 VSS INVR02
* cell instance $4361 r0 *1 830.08,5075.9
X$4361 \$18 \$15051 \$15935 VSS INVR03
* cell instance $4362 r0 *1 846.88,5075.9
X$4362 \$18 \$15495 \$15429 VSS INVR04
* cell instance $4364 r0 *1 869.79,5075.9
X$4364 \$18 \$15637 \$15495 VSS INVR06
* cell instance $4366 r0 *1 907.72,5075.9
X$4366 \$18 \$15635 \$15429 VSS INVR03
* cell instance $4370 r0 *1 943.25,5075.9
X$4370 \$18 \$15639 \$15363 VSS INVR06
* cell instance $4371 r0 *1 972.66,5075.9
X$4371 \$18 \$14046 \$15498 VSS INVR03
* cell instance $4376 r0 *1 1016.51,5075.9
X$4376 \$18 \$15062 \$15640 VSS INVR02
* cell instance $4380 r0 *1 1046.52,5075.9
X$4380 \$18 \$15058 \$15502 VSS INVR03
* cell instance $4384 r0 *1 1071.1,5075.9
X$4384 \$18 \$14393 \$15641 VSS INVR02
* cell instance $4387 r0 *1 1092.1,5075.9
X$4387 \$18 \$15363 \$15433 VSS INVR06
* cell instance $4390 r0 *1 1127.81,5075.9
X$4390 \$18 \$15363 \$15061 VSS INVR03
* cell instance $4392 r0 *1 1149.44,5075.9
X$4392 \$18 \$15641 \$15433 VSS INVR03
* cell instance $4400 r0 *1 1217.04,5075.9
X$4400 \$18 \$11152 \$14601 VSS INVR02
* cell instance $4403 r0 *1 1247.41,5075.9
X$4403 \$18 \$14601 \$15649 VSS INVR02
* cell instance $4406 m90 *1 1284.66,5075.9
X$4406 \$14471 \$14605 \$12421 \$18 VSS NND201
* cell instance $4408 r0 *1 1284.66,5075.9
X$4408 \$14601 \$18 \$15511 VSS INVR05
* cell instance $4409 r0 *1 1309.86,5075.9
X$4409 \$15652 \$18 \$15512 VSS INVR05
* cell instance $4411 r0 *1 1344.06,5075.9
X$4411 \$18 \$12421 \$15065 VSS INVR02
* cell instance $4420 r0 *1 1511.08,5075.9
X$4420 \$18 \$15070 \$15068 VSS INVR03
* cell instance $4431 r0 *1 1608.21,5075.9
X$4431 \$18 \$15517 \$15442 VSS INVR03
* cell instance $4438 r0 *1 1757.6,5075.9
X$4438 \$18 \$15519 \$15610 VSS INVR03
* cell instance $4439 r0 *1 1774.4,5075.9
X$4439 \$18 \$4800 \$15610 VSS INVR06
* cell instance $4441 m90 *1 1942.73,5075.9
X$4441 \$15525 \$18 \$15084 \$15377 \$14077 VSS AND301
* cell instance $4444 r0 *1 1955.94,5075.9
X$4444 \$18 \$12439 \$15082 VSS INVR02
* cell instance $4450 r0 *1 2002.74,5075.9
X$4450 \$18 \$15663 \$15961 \$14069 VSS AND201
* cell instance $4453 r0 *1 2036.52,5075.9
X$4453 \$18 \$15085 \$11375 \$15664 VSS AND201
* cell instance $4454 r0 *1 2061.72,5075.9
X$4454 \$18 \$15525 \$15665 VSS INVR02
* cell instance $4455 m90 *1 2091.12,5075.9
X$4455 \$15531 \$18 \$15097 VSS INVR01
* cell instance $4457 r0 *1 2093.83,5075.9
X$4457 \$15383 \$18 \$6055 VSS INVR05
* cell instance $4463 m90 *1 2205.3,5075.9
X$4463 \$15531 \$14761 \$18 \$14077 VSS OR2101
* cell instance $4472 r0 *1 2256.76,5075.9
X$4472 \$18 \$14080 \$15819 VSS INVR02
* cell instance $4475 m90 *1 2295.45,5075.9
X$4475 \$18 \$15256 \$15821 VSS INVR03
* cell instance $4479 r0 *1 2389.82,5075.9
X$4479 \$18 \$15102 \$15255 VSS INVR03
* cell instance $4480 r0 *1 2406.62,5075.9
X$4480 \$15537 \$18 \$15536 VSS INVR05
* cell instance $4481 r0 *1 2431.82,5075.9
X$4481 \$18 \$15537 \$15673 VSS INVR02
* cell instance $4485 r0 *1 2462.02,5075.9
X$4485 \$18 \$15675 \$15464 VSS INVR06
* cell instance $4486 r0 *1 2491.43,5075.9
X$4486 \$18 \$14638 \$15464 VSS INVR03
* cell instance $4488 m90 *1 2548.07,5075.9
X$4488 \$14341 \$14929 \$18 \$15545 \$12950 VSS NOR301
* cell instance $4490 m90 *1 2573.27,5075.9
X$4490 \$14099 \$15339 \$18 \$15461 VSS OR2101
* cell instance $4492 r0 *1 2575.37,5075.9
X$4492 \$15545 \$18 \$13449 VSS INVR01
* cell instance $4493 r0 *1 2587.97,5075.9
X$4493 \$15461 \$18 \$12458 VSS INVR01
* cell instance $4494 r0 *1 2600.57,5075.9
X$4494 \$15339 \$15541 \$18 \$13763 \$13616 VSS NOR301
* cell instance $4499 m90 *1 2677.37,5075.9
X$4499 \$18 \$14508 \$15552 VSS INVR03
* cell instance $4500 m90 *1 2698.37,5075.9
X$4500 \$14990 \$15683 \$18 \$15257 VSS OR2101
* cell instance $4501 r0 *1 2698.37,5075.9
X$4501 \$18 \$15683 \$15555 VSS INVR03
* cell instance $4507 r0 *1 2784.08,5075.9
X$4507 \$18 \$15688 \$15120 VSS INVR03
* cell instance $4510 r0 *1 2805.68,5075.9
X$4510 \$14104 \$18 \$15121 VSS INVR05
* cell instance $4511 r0 *1 2830.88,5075.9
X$4511 \$15688 \$11916 \$11916 \$18 VSS NND201
* cell instance $4512 r0 *1 2847.68,5075.9
X$4512 \$14657 \$15124 \$18 \$15445 VSS OR2101
* cell instance $4514 r0 *1 2871.14,5075.9
X$4514 \$18 \$15691 \$15692 VSS INVR02
* cell instance $4517 r0 *1 2895.19,5075.9
X$4517 \$18 \$15123 \$15563 VSS INVR02
* cell instance $4519 m90 *1 2928.8,5075.9
X$4519 \$15445 \$15125 \$15257 \$18 VSS NND201
* cell instance $4520 m90 *1 2954,5075.9
X$4520 \$18 \$15839 \$15137 \$8774 VSS AND201
* cell instance $4529 m90 *1 3053.88,5075.9
X$4529 \$18 \$15256 \$15129 VSS INVR04
* cell instance $4532 m90 *1 3079.68,5075.9
X$4532 \$18 \$14510 \$15126 VSS INVR02
* cell instance $4534 m90 *1 3096.48,5075.9
X$4534 \$18 \$10073 \$15696 VSS INVR02
* cell instance $4537 r0 *1 3107.83,5075.9
X$4537 \$18 \$15569 \$15758 VSS INVR02
* cell instance $4539 r0 *1 3124.63,5075.9
X$4539 \$18 \$15758 \$12944 VSS INVR02
* cell instance $4541 m90 *1 3162.85,5075.9
X$4541 \$18 \$15139 \$15571 VSS INVR03
* cell instance $4542 m90 *1 3179.65,5075.9
X$4542 \$18 \$15699 \$14510 VSS INVR03
* cell instance $4544 m90 *1 3209.27,5075.9
X$4544 \$18 \$11916 \$14664 VSS INVR04
* cell instance $4545 m90 *1 3242.87,5075.9
X$4545 \$14665 \$18 \$13623 \$14125 VSS NOR201
* cell instance $4546 r0 *1 3244.1,5075.9
X$4546 \$15701 \$15137 \$12945 \$18 VSS NND201
* cell instance $4550 r0 *1 3274.19,5075.9
X$4550 \$18 \$15702 \$12945 \$15137 VSS AND201
* cell instance $4552 r0 *1 3299.88,5075.9
X$4552 \$18 \$15703 \$15704 VSS INVR02
* cell instance $4556 r0 *1 3334.94,5075.9
X$4556 \$18 \$15138 \$15142 VSS INVR02
* cell instance $4557 m90 *1 3385.34,5075.9
X$4557 \$15705 \$18 \$14954 \$15275 VSS NOR201
* cell instance $4560 r0 *1 3396.21,5075.9
X$4560 \$15852 \$15576 \$15577 \$18 VSS NND201
* cell instance $4773 r0 *1 5104.73,5075.9
X$4773 \$18 \$15148 \$15578 VSS INVR03
* cell instance $4936 r0 *1 34.2,3656.7
X$4936 \$18 \$7469 \$7391 VSS INVR03
* cell instance $4944 r0 *1 194.41,3656.7
X$4944 \$18 \$7474 \$3859 VSS INVR06
* cell instance $4945 m90 *1 249.01,3656.7
X$4945 \$18 \$7471 \$7254 \$7477 VSS AND201
* cell instance $4950 r0 *1 276.95,3656.7
X$4950 \$18 \$7479 \$7478 \$7686 VSS AND201
* cell instance $4960 m90 *1 373.55,3656.7
X$4960 \$18 \$7482 \$7481 VSS INVR03
* cell instance $4961 r0 *1 373.55,3656.7
X$4961 \$18 \$6853 \$7484 VSS INVR02
* cell instance $4962 r0 *1 390.35,3656.7
X$4962 \$18 \$7397 \$7134 VSS INVR02
* cell instance $4965 r0 *1 420.61,3656.7
X$4965 \$18 \$7484 \$7488 VSS INVR02
* cell instance $4967 r0 *1 437.42,3656.7
X$4967 \$18 \$7489 \$7488 VSS INVR06
* cell instance $4969 m90 *1 500.98,3656.7
X$4969 \$18 \$7250 \$7254 \$7491 VSS AND201
* cell instance $4971 r0 *1 509.09,3656.7
X$4971 \$18 \$6855 \$6599 VSS INVR03
* cell instance $4972 r0 *1 525.9,3656.7
X$4972 \$18 \$7397 \$6482 \$6479 VSS AND201
* cell instance $4973 r0 *1 551.1,3656.7
X$4973 \$18 \$7493 \$6479 \$6482 VSS AND201
* cell instance $4975 r0 *1 579.36,3656.7
X$4975 \$7332 \$18 \$7494 VSS INVR05
* cell instance $4980 r0 *1 619.51,3656.7
X$4980 \$18 \$7495 \$7399 VSS INVR02
* cell instance $4981 r0 *1 737.11,3656.7
X$4981 \$18 \$7335 \$7594 VSS INVR02
* cell instance $4982 r0 *1 753.91,3656.7
X$4982 \$6482 \$18 \$7399 VSS INVR05
* cell instance $4986 r0 *1 800.44,3656.7
X$4986 \$18 \$7498 \$7499 VSS INVR02
* cell instance $4997 r0 *1 979.66,3656.7
X$4997 \$18 \$6459 \$7408 VSS INVR06
* cell instance $4998 r0 *1 1009.06,3656.7
X$4998 \$18 \$7504 \$7154 \$7328 VSS AND201
* cell instance $4999 r0 *1 1034.26,3656.7
X$4999 \$18 \$7505 \$7407 VSS INVR02
* cell instance $5002 m90 *1 1079.9,3656.7
X$5002 \$18 \$7152 \$6680 VSS INVR02
* cell instance $5003 r0 *1 1079.9,3656.7
X$5003 \$18 \$7508 \$7509 VSS INVR02
* cell instance $5004 r0 *1 1096.7,3656.7
X$5004 \$18 \$7339 \$7509 VSS INVR06
* cell instance $5005 r0 *1 1126.1,3656.7
X$5005 \$18 \$7511 \$7512 VSS INVR02
* cell instance $5006 r0 *1 1142.9,3656.7
X$5006 \$18 \$3227 \$7410 VSS INVR06
* cell instance $5007 r0 *1 1172.3,3656.7
X$5007 \$18 \$7513 \$7411 VSS INVR03
* cell instance $5008 r0 *1 1189.1,3656.7
X$5008 \$18 \$7504 \$6795 VSS INVR03
* cell instance $5011 r0 *1 1209.08,3656.7
X$5011 \$18 \$7515 \$6729 VSS INVR06
* cell instance $5012 r0 *1 1238.48,3656.7
X$5012 \$7515 \$7277 \$18 \$6870 VSS OR2101
* cell instance $5015 r0 *1 1272.38,3656.7
X$5015 \$18 \$7705 \$3408 VSS INVR06
* cell instance $5016 r0 *1 1301.78,3656.7
X$5016 \$18 \$7261 \$7410 VSS INVR04
* cell instance $5020 m90 *1 1418.28,3656.7
X$5020 \$18 \$7607 \$7606 VSS INVR02
* cell instance $5022 m90 *1 1460.91,3656.7
X$5022 \$6981 \$7278 \$7608 \$6344 \$6881 \$18 VSS AND401
* cell instance $5025 r0 *1 1473.69,3656.7
X$5025 \$7521 \$7058 \$18 \$6870 VSS OR2101
* cell instance $5029 m90 *1 1527.61,3656.7
X$5029 \$18 \$7523 \$6617 \$7261 VSS AND201
* cell instance $5030 r0 *1 1528.72,3656.7
X$5030 \$18 \$7168 \$7169 VSS INVR03
* cell instance $5034 r0 *1 1558.72,3656.7
X$5034 \$18 \$6806 \$7274 \$7526 VSS AND201
* cell instance $5037 m90 *1 1602.22,3656.7
X$5037 \$7283 \$18 \$7529 VSS INVR01
* cell instance $5039 r0 *1 1602.22,3656.7
X$5039 \$18 \$7355 \$7428 VSS INVR04
* cell instance $5040 r0 *1 1623.22,3656.7
X$5040 \$18 \$7429 \$7170 \$6616 VSS AND201
* cell instance $5041 r0 *1 1650.09,3656.7
X$5041 \$18 \$7529 \$7428 VSS INVR02
* cell instance $5043 m90 *1 1683.69,3656.7
X$5043 \$18 \$7431 \$6807 VSS INVR03
* cell instance $5046 r0 *1 1694.88,3656.7
X$5046 \$6346 \$18 \$7355 VSS INVR05
* cell instance $5048 r0 *1 1720.08,3656.7
X$5048 \$18 \$7538 \$7172 \$7431 VSS AND201
* cell instance $5052 m90 *1 1782.69,3656.7
X$5052 \$7429 \$7175 \$6346 \$18 \$7538 VSS OR3101
* cell instance $5053 r0 *1 1782.69,3656.7
X$5053 \$18 \$6644 \$7355 VSS INVR04
* cell instance $5062 r0 *1 1858.59,3656.7
X$5062 \$6903 \$7542 \$18 \$7180 VSS OR2101
* cell instance $5065 r0 *1 1891.16,3656.7
X$5065 \$18 \$7542 \$7544 VSS INVR02
* cell instance $5073 r0 *1 1951.16,3656.7
X$5073 \$18 \$7544 \$6821 VSS INVR03
* cell instance $5085 r0 *1 2039.36,3656.7
X$5085 \$18 \$7546 \$7582 VSS INVR02
* cell instance $5089 r0 *1 2062.32,3656.7
X$5089 \$18 \$7582 \$7187 VSS INVR02
* cell instance $5090 r0 *1 2079.12,3656.7
X$5090 \$18 \$7453 \$7549 VSS INVR03
* cell instance $5093 r0 *1 2109.12,3656.7
X$5093 \$18 \$7550 \$7453 VSS INVR02
* cell instance $5097 r0 *1 2139.12,3656.7
X$5097 \$18 \$7192 \$7188 VSS INVR03
* cell instance $5102 r0 *1 2169.12,3656.7
X$5102 \$18 \$6651 \$7553 VSS INVR06
* cell instance $5103 r0 *1 2199.12,3656.7
X$5103 \$18 \$6832 \$7579 VSS INVR02
* cell instance $5104 r0 *1 2215.92,3656.7
X$5104 \$18 \$7579 \$7555 VSS INVR03
* cell instance $5108 r0 *1 2244.13,3656.7
X$5108 \$18 \$6835 \$7556 VSS INVR06
* cell instance $5109 r0 *1 2275.5,3656.7
X$5109 \$18 \$6651 \$6834 VSS INVR03
* cell instance $5114 r0 *1 2303.53,3656.7
X$5114 \$18 \$7559 \$6913 VSS INVR06
* cell instance $5115 r0 *1 2332.93,3656.7
X$5115 \$18 \$6649 \$7195 VSS INVR02
* cell instance $5117 r0 *1 2355.11,3656.7
X$5117 \$18 \$7562 \$7563 VSS INVR03
* cell instance $5133 r0 *1 2511.28,3656.7
X$5133 \$18 \$7566 \$7567 VSS INVR02
* cell instance $5137 r0 *1 2534.2,3656.7
X$5137 \$18 \$7569 \$7568 VSS INVR06
* cell instance $5139 m90 *1 2582.75,3656.7
X$5139 \$18 \$7578 \$6918 VSS INVR02
* cell instance $5140 m90 *1 2599.55,3656.7
X$5140 \$18 \$7571 \$7578 VSS INVR02
* cell instance $5145 r0 *1 2625.94,3656.7
X$5145 \$18 \$7572 \$7573 VSS INVR02
* cell instance $5162 r0 *1 2772.43,3656.7
X$5162 \$18 \$7574 \$7575 VSS INVR02
* cell instance $5333 r0 *1 4143.05,3656.7
X$5333 \$18 \$7203 \$7291 VSS INVR03
* cell instance $5765 r0 *1 7591.04,3656.7
X$5765 \$18 \$7577 \$7292 VSS INVR04
* cell instance $5928 m90 *1 51,2947.1
X$5928 \$18 \$4683 \$4870 VSS INVR03
* cell instance $5931 r0 *1 54.46,2947.1
X$5931 \$18 \$4966 \$5107 VSS INVR06
* cell instance $5932 r0 *1 83.86,2947.1
X$5932 \$18 \$4872 \$4584 VSS INVR02
* cell instance $5939 r0 *1 140.3,2947.1
X$5939 \$5109 \$4791 \$5020 \$18 VSS XNR201
* cell instance $5941 r0 *1 178.1,2947.1
X$5941 \$18 \$5110 \$5228 VSS INVR02
* cell instance $5942 r0 *1 194.9,2947.1
X$5942 \$5111 \$4737 \$4803 \$18 VSS NND201
* cell instance $5945 r0 *1 218,2947.1
X$5945 \$18 \$5314 \$5109 \$4310 VSS AND201
* cell instance $5948 r0 *1 256.46,2947.1
X$5948 \$4690 \$923 \$18 \$4418 \$4088 VSS NOR301
* cell instance $5952 r0 *1 404.97,2947.1
X$5952 \$18 \$5025 \$5119 VSS INVR02
* cell instance $5954 r0 *1 425.98,2947.1
X$5954 \$18 \$5120 \$5198 VSS INVR02
* cell instance $5955 r0 *1 442.78,2947.1
X$5955 \$18 \$5198 \$5025 VSS INVR02
* cell instance $5956 r0 *1 460.18,2947.1
X$5956 \$18 \$5122 \$5111 \$4796 VSS AND201
* cell instance $5960 r0 *1 499.84,2947.1
X$5960 \$18 \$5123 \$5238 VSS INVR02
* cell instance $5962 r0 *1 520.18,2947.1
X$5962 \$4972 \$4884 \$3618 \$4976 \$5125 \$4798 \$4103 \$18 VSS NOR601
* cell instance $5964 r0 *1 574.78,2947.1
X$5964 \$4972 \$18 \$5126 VSS INVR01
* cell instance $5965 r0 *1 589.28,2947.1
X$5965 \$5126 \$18 \$5127 VSS INVR01
* cell instance $5967 r0 *1 601.88,2947.1
X$5967 \$18 \$5129 \$5031 VSS INVR03
* cell instance $5976 m90 *1 692.17,2947.1
X$5976 \$4976 \$18 \$4807 VSS INVR01
* cell instance $5998 r0 *1 857.49,2947.1
X$5998 \$18 \$3880 \$5034 VSS INVR02
* cell instance $6002 r0 *1 891.5,2947.1
X$6002 \$18 \$5034 \$5131 VSS INVR02
* cell instance $6007 r0 *1 923.11,2947.1
X$6007 \$18 \$5036 \$5102 VSS INVR03
* cell instance $6008 r0 *1 939.91,2947.1
X$6008 \$18 \$4113 \$5102 VSS INVR06
* cell instance $6009 r0 *1 969.31,2947.1
X$6009 \$18 \$5037 \$5036 VSS INVR02
* cell instance $6013 r0 *1 1011.86,2947.1
X$6013 \$5037 \$18 \$5042 \$5011 \$5132 VSS ADNR01
* cell instance $6017 r0 *1 1043.99,2947.1
X$6017 \$18 \$5134 \$5133 \$5011 VSS AND201
* cell instance $6018 r0 *1 1069.19,2947.1
X$6018 \$18 \$4894 \$5135 VSS INVR03
* cell instance $6019 m90 *1 1103.53,2947.1
X$6019 \$18 \$5044 \$5136 VSS INVR02
* cell instance $6024 r0 *1 1129.33,2947.1
X$6024 \$18 \$5138 \$4818 VSS INVR06
* cell instance $6025 r0 *1 1158.73,2947.1
X$6025 \$18 \$5063 \$5046 VSS INVR06
* cell instance $6030 m90 *1 1288.36,2947.1
X$6030 \$5141 \$18 \$5049 VSS INVR05
* cell instance $6033 m90 *1 1313.37,2947.1
X$6033 \$18 \$5210 \$5049 VSS INVR02
* cell instance $6037 m90 *1 1338.15,2947.1
X$6037 \$18 \$5051 \$5210 VSS INVR02
* cell instance $6038 r0 *1 1338.16,2947.1
X$6038 \$18 \$5052 \$5053 VSS INVR03
* cell instance $6041 m90 *1 1384.97,2947.1
X$6041 \$18 \$4898 \$5142 VSS INVR02
* cell instance $6043 r0 *1 1468.98,2947.1
X$6043 \$18 \$4794 \$3889 VSS INVR03
* cell instance $6044 r0 *1 1485.78,2947.1
X$6044 \$18 \$5147 \$4820 \$4902 VSS AND201
* cell instance $6045 r0 *1 1510.98,2947.1
X$6045 \$18 \$5339 \$5149 \$5011 VSS AND201
* cell instance $6048 r0 *1 1548.93,2947.1
X$6048 \$18 \$4550 \$5247 VSS INVR06
* cell instance $6049 r0 *1 1578.33,2947.1
X$6049 \$18 \$5107 \$4985 VSS INVR06
* cell instance $6050 r0 *1 1607.73,2947.1
X$6050 \$4821 \$5151 \$18 \$5009 VSS OR2101
* cell instance $6054 m90 *1 1672.35,2947.1
X$6054 \$18 \$4901 \$5061 \$4902 VSS AND201
* cell instance $6057 r0 *1 1679.12,2947.1
X$6057 \$18 \$5009 \$5063 VSS INVR06
* cell instance $6058 m90 *1 1729.52,2947.1
X$6058 \$4901 \$4985 \$18 \$5153 VSS OR2101
* cell instance $6059 m90 *1 1746.32,2947.1
X$6059 \$18 \$4905 \$5061 VSS INVR03
* cell instance $6060 r0 *1 1746.32,2947.1
X$6060 \$18 \$5151 \$5156 VSS INVR03
* cell instance $6061 r0 *1 1764.29,2947.1
X$6061 \$18 \$5158 \$5157 \$5255 VSS AND201
* cell instance $6063 r0 *1 1789.5,2947.1
X$6063 \$4987 \$5160 \$18 \$5068 VSS OR2101
* cell instance $6065 r0 *1 1812.71,2947.1
X$6065 \$18 \$2835 \$4619 VSS INVR06
* cell instance $6066 r0 *1 1842.12,2947.1
X$6066 \$18 \$5161 \$4823 VSS INVR02
* cell instance $6074 r0 *1 1915.32,2947.1
X$6074 \$18 \$3655 \$3655 VSS INVR02
* cell instance $6075 r0 *1 1932.67,2947.1
X$6075 \$18 \$5162 \$5346 VSS INVR02
* cell instance $6076 r0 *1 1949.47,2947.1
X$6076 \$18 \$5260 \$5074 VSS INVR02
* cell instance $6078 m90 *1 2000.13,2947.1
X$6078 \$18 \$4911 \$5076 \$4629 VSS AND201
* cell instance $6079 r0 *1 2000.14,2947.1
X$6079 \$5165 \$18 \$2838 VSS INVR05
* cell instance $6080 r0 *1 2025.34,2947.1
X$6080 \$18 \$4837 \$5166 VSS INVR02
* cell instance $6082 m90 *1 2067.46,2947.1
X$6082 \$18 \$5167 \$4838 VSS INVR02
* cell instance $6083 r0 *1 2067.47,2947.1
X$6083 \$18 \$5166 \$4632 VSS INVR02
* cell instance $6087 m90 *1 2135.71,2947.1
X$6087 \$4841 \$18 \$4920 \$4923 VSS NOR201
* cell instance $6088 r0 *1 2135.71,2947.1
X$6088 \$18 \$5263 \$5167 VSS INVR02
* cell instance $6092 m90 *1 2190.55,2947.1
X$6092 \$18 \$3743 \$4469 VSS INVR02
* cell instance $6095 m90 *1 2212.51,2947.1
X$6095 \$18 \$4635 \$4368 VSS INVR02
* cell instance $6098 r0 *1 2216.34,2947.1
X$6098 \$18 \$5174 \$4755 VSS INVR03
* cell instance $6101 m90 *1 2263.14,2947.1
X$6101 \$18 \$5084 \$2835 \$4995 VSS AND201
* cell instance $6103 m90 *1 2289.44,2947.1
X$6103 \$18 \$4848 \$4636 VSS INVR02
* cell instance $6106 r0 *1 2293.15,2947.1
X$6106 \$18 \$5084 \$5088 VSS INVR02
* cell instance $6112 r0 *1 2339.03,2947.1
X$6112 \$18 \$2835 \$4852 VSS INVR02
* cell instance $6118 r0 *1 2378.15,2947.1
X$6118 \$4564 \$5090 \$5180 \$4853 \$5179 \$18 VSS NND401
* cell instance $6121 r0 *1 2441.29,2947.1
X$6121 \$5183 \$18 \$5179 \$4564 \$5180 VSS NND301
* cell instance $6124 m90 *1 2513.17,2947.1
X$6124 \$18 \$4857 \$5184 VSS INVR02
* cell instance $6129 r0 *1 2528.89,2947.1
X$6129 \$18 \$5179 \$5191 VSS INVR02
* cell instance $6132 r0 *1 2551.35,2947.1
X$6132 \$18 \$5191 \$4566 VSS INVR03
* cell instance $6509 r0 *1 5565,2947.1
X$6509 \$5093 \$18 \$2296 VSS INVR05
* cell instance $6537 r0 *1 5795.27,2947.1
X$6537 \$18 \$5187 \$5093 VSS INVR06
* cell instance $30800 m0 *1 3948.77,8761.3
X$30800 \$18 \$20813 \$20853 VSS INVR02
* cell instance $30802 r180 *1 3988.08,8761.3
X$30802 \$18 \$19928 \$20813 VSS INVR02
* cell instance $30812 m0 *1 4041.89,8761.3
X$30812 \$18 \$18989 \$20854 VSS INVR02
* cell instance $30818 r180 *1 4105.92,8761.3
X$30818 \$18 \$18718 \$20855 VSS INVR02
* cell instance $30824 m0 *1 4146.93,8761.3
X$30824 \$18 \$19938 \$20815 VSS INVR02
* cell instance $30827 r180 *1 4192.83,8761.3
X$30827 \$18 \$18993 \$20856 VSS INVR02
* cell instance $30830 m0 *1 4209.13,8761.3
X$30830 \$18 \$19939 \$20857 VSS INVR02
* cell instance $30835 m0 *1 4249.03,8761.3
X$30835 \$18 \$20815 \$20858 VSS INVR02
* cell instance $30842 r180 *1 4312.87,8761.3
X$30842 \$18 \$20877 \$20859 VSS INVR02
* cell instance $30845 r180 *1 4337.3,8761.3
X$30845 \$18 \$19940 \$20877 VSS INVR02
* cell instance $30849 r180 *1 4365.67,8761.3
X$30849 \$18 \$20794 \$20860 VSS INVR02
* cell instance $30853 m0 *1 4379.3,8761.3
X$30853 \$18 \$19929 \$20794 VSS INVR02
* cell instance $30861 m0 *1 4438.28,8761.3
X$30861 \$18 \$20628 \$20822 VSS INVR02
* cell instance $30864 m0 *1 4462.64,8761.3
X$30864 \$18 \$20674 \$20716 VSS INVR03
* cell instance $30869 m0 *1 4497.57,8761.3
X$30869 \$18 \$20822 \$20824 VSS INVR02
* cell instance $30877 m0 *1 4560.51,8761.3
X$30877 \$18 \$20796 \$20596 VSS INVR02
* cell instance $30880 m0 *1 4593.68,8761.3
X$30880 \$18 \$20734 \$20636 VSS INVR03
* cell instance $30881 m0 *1 4610.48,8761.3
X$30881 \$18 \$20415 \$20683 VSS INVR03
* cell instance $30882 m0 *1 4627.28,8761.3
X$30882 \$18 \$20782 \$20599 VSS INVR02
* cell instance $30883 m0 *1 4644.08,8761.3
X$30883 \$20865 \$18 \$20723 VSS INVR01
* cell instance $30886 m0 *1 4718.03,8761.3
X$30886 \$18 \$20717 \$20796 VSS INVR02
* cell instance $30887 m0 *1 4734.83,8761.3
X$30887 \$18 \$20596 \$20719 VSS INVR02
* cell instance $30890 m0 *1 4764.83,8761.3
X$30890 \$18 \$20493 \$20734 VSS INVR02
* cell instance $30892 r180 *1 4799.58,8761.3
X$30892 \$18 \$20420 \$20802 VSS INVR02
* cell instance $30894 r180 *1 4816.39,8761.3
X$30894 \$18 \$20683 \$20866 VSS INVR02
* cell instance $30895 r180 *1 4833.19,8761.3
X$30895 \$18 \$20802 \$20738 VSS INVR02
* cell instance $30896 m0 *1 4833.19,8761.3
X$30896 \$18 \$20636 \$20658 VSS INVR03
* cell instance $30897 m0 *1 4850.86,8761.3
X$30897 \$18 \$20413 \$20230 VSS INVR04
* cell instance $30900 m0 *1 4900.54,8761.3
X$30900 \$18 \$20041 \$19918 VSS INVR03
* cell instance $30903 r180 *1 4938.9,8761.3
X$30903 \$18 \$19918 \$20832 VSS INVR02
* cell instance $30904 r180 *1 4955.7,8761.3
X$30904 \$18 \$19918 \$20874 VSS INVR02
* cell instance $30907 r180 *1 4985.7,8761.3
X$30907 \$18 \$20833 \$20801 VSS INVR03
* cell instance $30911 m0 *1 4996.9,8761.3
X$30911 \$18 \$20833 \$20884 VSS INVR03
* cell instance $30913 m0 *1 5013.7,8761.3
X$30913 \$18 \$20693 \$20884 VSS INVR06
* cell instance $30914 r180 *1 5059.9,8761.3
X$30914 \$18 \$20834 \$20833 VSS INVR03
* cell instance $30917 r180 *1 5172.15,8761.3
X$30917 \$8743 \$20427 \$20702 \$I331378 \$20834 \$18 VSS DFCL11
* cell instance $30919 r180 *1 5201.56,8761.3
X$30919 \$18 \$20569 \$20612 VSS INVR06
* cell instance $30921 m0 *1 5203.53,8761.3
X$30921 \$18 \$19942 \$20427 VSS INVR06
* cell instance $31380 m0 *1 4162.2,8406.5
X$31380 \$18 \$20280 \$20281 VSS INVR03
* cell instance $31401 m0 *1 4332.9,8406.5
X$31401 \$18 \$20196 \$20437 VSS INVR02
* cell instance $31403 m0 *1 4354.51,8406.5
X$31403 \$18 \$20157 \$20184 \$20196 VSS AND201
* cell instance $31404 m0 *1 4379.72,8406.5
X$31404 \$18 \$20156 \$20311 VSS INVR03
* cell instance $31405 m0 *1 4396.52,8406.5
X$31405 \$18 \$20245 \$20311 VSS INVR06
* cell instance $31406 m0 *1 4425.92,8406.5
X$31406 \$18 \$19886 \$20245 VSS INVR06
* cell instance $31408 r180 *1 4476.42,8406.5
X$31408 \$18 \$20287 \$20158 VSS INVR03
* cell instance $31410 r180 *1 4495.55,8406.5
X$31410 \$18 \$20246 \$20159 VSS INVR03
* cell instance $31411 m0 *1 4495.55,8406.5
X$31411 \$18 \$19889 \$20314 VSS INVR02
* cell instance $31415 m0 *1 4630.56,8406.5
X$31415 \$18 \$20122 \$20289 VSS INVR03
* cell instance $31418 m0 *1 4665.36,8406.5
X$31418 \$18 \$20324 \$20323 \$20290 VSS AND201
* cell instance $31421 r180 *1 4726.49,8406.5
X$31421 \$19956 \$18 \$20326 \$20291 VSS NOR201
* cell instance $31423 m0 *1 4735.47,8406.5
X$31423 \$20190 \$18 \$20251 \$20293 VSS NOR201
* cell instance $31424 m0 *1 4769.08,8406.5
X$31424 \$18 \$19965 \$20191 VSS INVR02
* cell instance $31425 m0 *1 4785.88,8406.5
X$31425 \$18 \$20293 \$20289 \$20196 VSS AND201
* cell instance $31429 m0 *1 4876.17,8406.5
X$31429 \$8743 \$20232 \$20268 \$I331420 \$20203 \$18 VSS DFCL11
* cell instance $31430 m0 *1 4976.97,8406.5
X$31430 \$18 \$19874 \$20199 VSS INVR06
* cell instance $31433 r180 *1 5094.58,8406.5
X$31433 \$18 \$20169 \$20300 \$20204 VSS AND201
* cell instance $31435 m0 *1 5099.38,8406.5
X$31435 \$18 \$20300 \$20063 VSS INVR06
* cell instance $31439 r180 *1 5173.84,8406.5
X$31439 \$18 \$20205 \$20265 VSS INVR06
* cell instance $31441 r180 *1 5190.64,8406.5
X$31441 \$18 \$20174 \$20265 VSS INVR02
* cell instance $31443 r180 *1 5210.98,8406.5
X$31443 \$18 \$20133 \$20174 VSS INVR02
* cell instance $31445 m0 *1 5210.98,8406.5
X$31445 \$18 \$20305 \$20268 VSS INVR03
* cell instance $31446 m0 *1 5227.79,8406.5
X$31446 \$18 \$20230 \$20304 VSS INVR04
* cell instance $31447 m0 *1 5250.8,8406.5
X$31447 \$18 \$20207 \$20308 VSS INVR03
* cell instance $31903 m0 *1 1476.11,8583.9
X$31903 \$18 \$19937 \$20510 VSS INVR06
* cell instance $32074 m0 *1 2852.9,8583.9
X$32074 \$18 \$20510 \$20532 VSS INVR06
* cell instance $32232 m0 *1 4222.35,8583.9
X$32232 \$18 \$19656 \$20534 VSS INVR02
* cell instance $32236 r180 *1 4274.76,8583.9
X$32236 \$18 \$20536 \$20360 VSS INVR03
* cell instance $32243 m0 *1 4357.01,8583.9
X$32243 \$20486 \$20537 \$20362 \$18 VSS XNR201
* cell instance $32245 r180 *1 4442.73,8583.9
X$32245 \$20402 \$20189 \$20246 \$20410 \$20196 \$18 VSS AOI401
* cell instance $32246 m0 *1 4442.73,8583.9
X$32246 \$18 \$20361 \$20537 \$20397 VSS AND201
* cell instance $32250 r180 *1 4501.11,8583.9
X$32250 \$18 \$20627 \$20400 \$20542 VSS AND201
* cell instance $32253 m0 *1 4514.68,8583.9
X$32253 \$18 \$20364 \$20545 VSS INVR02
* cell instance $32255 r180 *1 4565.09,8583.9
X$32255 \$20406 \$18 \$20400 \$20547 \$20486 VSS AND301
* cell instance $32258 m0 *1 4571.94,8583.9
X$32258 \$18 \$20548 \$20486 VSS INVR02
* cell instance $32259 m0 *1 4588.74,8583.9
X$32259 \$20634 \$18 \$20596 VSS INVR01
* cell instance $32260 m0 *1 4602.33,8583.9
X$32260 \$18 \$20493 \$20411 VSS INVR03
* cell instance $32261 m0 *1 4619.14,8583.9
X$32261 \$18 \$20550 \$20494 VSS INVR02
* cell instance $32264 r180 *1 4681.03,8583.9
X$32264 \$20455 \$20407 \$18 \$20494 \$20600 VSS NOR301
* cell instance $32266 r180 *1 4693.63,8583.9
X$32266 \$20497 \$18 \$20455 VSS INVR01
* cell instance $32268 r180 *1 4715.53,8583.9
X$32268 \$18 \$20289 \$20460 VSS INVR02
* cell instance $32270 m0 *1 4715.62,8583.9
X$32270 \$19964 \$18 \$19979 VSS INVR05
* cell instance $32271 m0 *1 4740.83,8583.9
X$32271 \$18 \$20163 \$20420 VSS INVR03
* cell instance $32277 m0 *1 4891.99,8583.9
X$32277 \$20514 \$18 \$20300 \$20559 \$20418 VSS AND301
* cell instance $32279 r180 *1 4958.97,8583.9
X$32279 \$18 \$20567 \$20644 \$20165 VSS AND201
* cell instance $32281 m0 *1 4963.78,8583.9
X$32281 \$18 \$20200 \$20205 \$20130 VSS AND201
* cell instance $32284 m0 *1 4999.61,8583.9
X$32284 \$18 \$19918 \$20565 VSS INVR02
* cell instance $32285 m0 *1 5016.41,8583.9
X$32285 \$18 \$19411 \$8743 VSS INVR02
* cell instance $32286 m0 *1 5033.21,8583.9
X$32286 \$20198 \$18 \$20514 \$20567 VSS NOR201
* cell instance $32290 r180 *1 5118.84,8583.9
X$32290 \$20308 \$20569 \$20383 \$18 VSS XNR201
* cell instance $32292 r180 *1 5161.28,8583.9
X$32292 \$20511 \$20256 \$20609 \$18 VSS XNR201
* cell instance $32293 m0 *1 5161.28,8583.9
X$32293 \$18 \$20573 \$20586 VSS INVR03
* cell instance $32294 m0 *1 5178.09,8583.9
X$32294 \$18 \$20384 \$20586 VSS INVR06
* cell instance $32295 m0 *1 5207.49,8583.9
X$32295 \$18 \$20429 \$20305 VSS INVR02
* cell instance $32296 m0 *1 5224.29,8583.9
X$32296 \$18 \$20232 \$20573 VSS INVR03
* cell instance $32297 r180 *1 5262.09,8583.9
X$32297 \$20308 \$20511 \$18 \$20612 VSS OR2101
* cell instance $32752 m0 *1 4176.3,8229.1
X$32752 \$18 \$20104 \$20115 VSS INVR02
* cell instance $32760 m0 *1 4243.5,8229.1
X$32760 \$18 \$20116 \$20318 VSS INVR02
* cell instance $32765 r180 *1 4395.07,8229.1
X$32765 \$8743 \$19940 \$20118 \$I331361 \$20210 \$18 VSS DFCL11
* cell instance $32781 m0 *1 4498.72,8229.1
X$32781 \$18 \$20071 \$20186 VSS INVR02
* cell instance $32787 m0 *1 4548.6,8229.1
X$32787 \$18 \$19975 \$20108 VSS INVR02
* cell instance $32790 m0 *1 4570.13,8229.1
X$32790 \$18 \$20119 \$19975 VSS INVR02
* cell instance $32798 m0 *1 4636.8,8229.1
X$32798 \$18 \$20093 \$20122 VSS INVR02
* cell instance $32799 r180 *1 4756.06,8229.1
X$32799 \$8743 \$20094 \$20123 \$I331363 \$20093 \$18 VSS DFCL11
* cell instance $32801 r180 *1 4772.86,8229.1
X$32801 \$18 \$19965 \$20163 VSS INVR02
* cell instance $32806 m0 *1 4837.47,8229.1
X$32806 \$20060 \$18 \$20128 VSS INVR05
* cell instance $32807 r180 *1 4879.47,8229.1
X$32807 \$18 \$20113 \$20127 VSS INVR02
* cell instance $32833 m0 *1 5073.8,8229.1
X$32833 \$20130 \$18 \$20062 VSS INVR05
* cell instance $32849 m0 *1 5213.31,8229.1
X$32849 \$18 \$20132 \$20133 VSS INVR02
* cell instance $33308 r180 *1 4590.03,7696.9
X$33308 \$18 \$19975 \$19859 VSS INVR06
* cell instance $33849 r180 *1 194.16,5390.7
X$33849 \$16516 \$17091 \$18 \$16981 VSS OR2101
* cell instance $33851 m0 *1 194.17,5390.7
X$33851 \$18 \$17091 \$16983 VSS INVR02
* cell instance $33856 r180 *1 261.57,5390.7
X$33856 \$18 \$16981 \$16683 \$16985 VSS AND201
* cell instance $33857 m0 *1 261.58,5390.7
X$33857 \$18 \$16986 \$16518 VSS INVR02
* cell instance $33858 m0 *1 278.38,5390.7
X$33858 \$18 \$15034 \$16683 VSS INVR02
* cell instance $33860 m0 *1 297.98,5390.7
X$33860 \$14440 \$16987 \$16878 \$18 VSS NND201
* cell instance $33864 r180 *1 354.87,5390.7
X$33864 \$18 \$16878 \$16990 \$16991 VSS AND201
* cell instance $33866 r180 *1 374.96,5390.7
X$33866 \$18 \$17119 \$17118 VSS INVR03
* cell instance $33869 m0 *1 384.1,5390.7
X$33869 \$17120 \$18 \$16406 VSS INVR05
* cell instance $33872 m0 *1 418.55,5390.7
X$33872 \$16521 \$16520 \$16523 \$18 VSS NND201
* cell instance $33879 m0 *1 469.49,5390.7
X$33879 \$16943 \$18 \$17121 VSS INVR05
* cell instance $33881 m0 *1 499.56,5390.7
X$33881 \$18 \$16081 \$15032 VSS INVR02
* cell instance $33882 m0 *1 516.36,5390.7
X$33882 \$18 \$16084 \$16994 \$16077 VSS AND201
* cell instance $33894 m0 *1 672.18,5390.7
X$33894 \$18 \$16539 \$16998 VSS INVR02
* cell instance $33895 m0 *1 688.98,5390.7
X$33895 \$16999 \$18 \$16998 VSS INVR05
* cell instance $33898 m0 *1 724.74,5390.7
X$33898 \$17122 \$18 \$16527 VSS INVR05
* cell instance $33901 m0 *1 760.19,5390.7
X$33901 \$18 \$16532 \$17219 VSS INVR03
* cell instance $33902 m0 *1 776.99,5390.7
X$33902 \$16532 \$16699 \$18 \$15633 VSS OR2101
* cell instance $33903 m0 *1 797.99,5390.7
X$33903 \$18 \$17122 \$16547 VSS INVR03
* cell instance $33907 m0 *1 836.62,5390.7
X$33907 \$17002 \$16547 \$17124 \$18 VSS NND201
* cell instance $33911 m0 *1 864.5,5390.7
X$33911 \$18 \$16550 \$15489 VSS INVR03
* cell instance $33914 m0 *1 885.79,5390.7
X$33914 \$18 \$17004 \$16548 VSS INVR06
* cell instance $33915 m0 *1 915.19,5390.7
X$33915 \$18 \$16553 \$16705 VSS INVR03
* cell instance $33916 r180 *1 948.79,5390.7
X$33916 \$18 \$16707 \$16409 VSS INVR02
* cell instance $33917 r180 *1 969.79,5390.7
X$33917 \$17004 \$16704 \$18 \$16409 VSS OR2101
* cell instance $33919 r180 *1 995.8,5390.7
X$33919 \$17004 \$17006 \$18 \$14051 VSS OR2101
* cell instance $33922 r180 *1 1016.59,5390.7
X$33922 \$18 \$17008 \$16556 VSS INVR02
* cell instance $33928 r180 *1 1070.25,5390.7
X$33928 \$18 \$16103 \$17010 VSS INVR02
* cell instance $33931 m0 *1 1083.45,5390.7
X$33931 \$18 \$16562 \$16563 VSS INVR03
* cell instance $33935 m0 *1 1204.91,5390.7
X$33935 \$18 \$16111 \$17014 VSS INVR03
* cell instance $33942 m0 *1 1260.01,5390.7
X$33942 \$18 \$17017 \$16564 VSS INVR06
* cell instance $33943 m0 *1 1289.41,5390.7
X$33943 \$18 \$17019 \$16117 VSS INVR06
* cell instance $33944 m0 *1 1318.81,5390.7
X$33944 \$16571 \$16120 \$18 \$16568 VSS OR2101
* cell instance $33946 r180 *1 1365.61,5390.7
X$33946 \$17021 \$17022 \$16717 \$18 VSS NND201
* cell instance $33949 r180 *1 1384.89,5390.7
X$33949 \$18 \$16122 \$17022 VSS INVR03
* cell instance $33953 m0 *1 1400.5,5390.7
X$33953 \$17024 \$18 \$16121 VSS INVR05
* cell instance $33955 m0 *1 1528.22,5390.7
X$33955 \$18 \$16575 \$16576 VSS INVR02
* cell instance $33967 r180 *1 1646.31,5390.7
X$33967 \$18 \$16417 \$14069 \$16133 VSS AND201
* cell instance $33968 m0 *1 1646.31,5390.7
X$33968 \$18 \$17026 \$17027 VSS INVR03
* cell instance $33969 m0 *1 1663.11,5390.7
X$33969 \$16895 \$17029 \$18 \$17028 VSS OR2101
* cell instance $33974 r180 *1 1734.5,5390.7
X$33974 \$18 \$16729 \$17030 VSS INVR02
* cell instance $33976 r180 *1 1759.71,5390.7
X$33976 \$11869 \$18 \$17031 VSS INVR05
* cell instance $34023 r180 *1 2153.66,5390.7
X$34023 \$18 \$17032 \$16744 \$16871 VSS AND201
* cell instance $34025 r180 *1 2183.15,5390.7
X$34025 \$18 \$17034 \$16744 \$16871 VSS AND201
* cell instance $34029 r180 *1 2226.33,5390.7
X$34029 \$11182 \$17035 \$17036 \$18 \$14214 VSS OR3101
* cell instance $34030 r180 *1 2238.94,5390.7
X$34030 \$16742 \$18 \$13584 VSS INVR01
* cell instance $34031 m0 *1 2240.1,5390.7
X$34031 \$18 \$16302 \$17037 VSS INVR03
* cell instance $34035 m0 *1 2269.36,5390.7
X$34035 \$18 \$15555 \$17039 VSS INVR02
* cell instance $34041 m0 *1 2316.22,5390.7
X$34041 \$18 \$17206 \$17040 VSS INVR02
* cell instance $34044 r180 *1 2361.05,5390.7
X$34044 \$18 \$14214 \$17041 VSS INVR04
* cell instance $34047 r180 *1 2382.02,5390.7
X$34047 \$18 \$14781 \$14216 VSS INVR03
* cell instance $34050 m0 *1 2393.03,5390.7
X$34050 \$14781 \$18 \$14636 \$13435 \$16164 VSS ADNR01
* cell instance $34054 m0 *1 2444.05,5390.7
X$34054 \$16617 \$10058 \$16170 \$18 VSS NND201
* cell instance $34057 r180 *1 2479.72,5390.7
X$34057 \$18 \$10061 \$17041 VSS INVR02
* cell instance $34062 r180 *1 2520.85,5390.7
X$34062 \$18 \$17049 \$16176 \$15112 VSS AND201
* cell instance $34063 r180 *1 2546.09,5390.7
X$34063 \$18 \$17232 \$16619 \$17049 VSS AND201
* cell instance $34070 m0 *1 2584.23,5390.7
X$34070 \$18 \$16612 \$17054 VSS INVR02
* cell instance $34082 m0 *1 2686.53,5390.7
X$34082 \$18 \$16908 \$17139 VSS INVR02
* cell instance $34084 m0 *1 2704.06,5390.7
X$34084 \$17240 \$16180 \$17140 \$18 VSS NND201
* cell instance $34085 m0 *1 2720.86,5390.7
X$34085 \$18 \$15836 \$17055 VSS INVR03
* cell instance $34086 r180 *1 2771.27,5390.7
X$34086 \$18 \$16912 \$16871 VSS INVR03
* cell instance $34089 r180 *1 2827.19,5390.7
X$34089 \$15839 \$17058 \$17057 \$16639 \$16764 \$18 VSS AOI401
* cell instance $34090 r180 *1 2843.99,5390.7
X$34090 \$18 \$16914 \$16912 VSS INVR02
* cell instance $34093 r180 *1 2878.19,5390.7
X$34093 \$16761 \$16914 \$18 \$11906 VSS OR2101
* cell instance $34095 m0 *1 2878.19,5390.7
X$34095 \$18 \$17063 \$16178 VSS INVR02
* cell instance $34098 r180 *1 2934.87,5390.7
X$34098 \$18 \$14483 \$16651 VSS INVR06
* cell instance $34103 r180 *1 3011.81,5390.7
X$34103 \$18 \$11737 \$16642 VSS INVR03
* cell instance $34106 m0 *1 3021.51,5390.7
X$34106 \$18 \$13757 \$16196 VSS INVR06
* cell instance $34111 m0 *1 3084.84,5390.7
X$34111 \$17071 \$18 \$12176 \$16775 VSS NOR201
* cell instance $34112 m0 *1 3119.04,5390.7
X$34112 \$18 \$14125 \$15828 VSS INVR06
* cell instance $34117 r180 *1 3202.03,5390.7
X$34117 \$16204 \$18 \$17074 \$14125 VSS NOR201
* cell instance $34118 r180 *1 3269.23,5390.7
X$34118 \$14936 \$16775 \$16764 \$18 VSS PDDR02
* cell instance $34121 r180 *1 3298.73,5390.7
X$34121 \$18 \$16328 \$16450 VSS INVR03
* cell instance $34122 r180 *1 3332.33,5390.7
X$34122 \$17076 \$18 \$13623 \$17077 VSS NOR201
* cell instance $34125 m0 *1 3344.5,5390.7
X$34125 \$17078 \$17080 \$18 \$9937 VSS OR2101
* cell instance $34130 m0 *1 3391.36,5390.7
X$34130 \$18 \$17080 \$17082 VSS INVR02
* cell instance $34135 r180 *1 3457.2,5390.7
X$34135 \$16761 \$18 \$17082 VSS INVR05
* cell instance $34319 m0 *1 4904.95,5390.7
X$34319 \$18 \$16658 \$16657 VSS INVR02
* cell instance $34522 m0 *1 6523.74,5390.7
X$34522 \$18 \$16661 \$17085 VSS INVR02
* cell instance $34526 m0 *1 6565.51,5390.7
X$34526 \$18 \$17085 \$17086 VSS INVR02
* cell instance $34527 m0 *1 6582.31,5390.7
X$34527 \$18 \$17087 \$17086 VSS INVR06
* cell instance $34551 r180 *1 6825.68,5390.7
X$34551 \$16228 \$17087 \$16227 \$17088 \$16928 \$18 VSS NOR401
* cell instance $34556 r180 *1 6871.78,5390.7
X$34556 \$16928 \$18 \$16671 VSS INVR01
* cell instance $34813 r180 *1 187.27,5213.3
X$34813 \$18 \$15911 \$15910 VSS INVR03
* cell instance $34814 m0 *1 187.27,5213.3
X$34814 \$15481 \$18 \$14030 VSS INVR05
* cell instance $34818 m0 *1 271.26,5213.3
X$34818 \$18 \$13549 \$16403 VSS INVR02
* cell instance $34820 r180 *1 304.86,5213.3
X$34820 \$16269 \$12857 \$15617 \$18 VSS NND201
* cell instance $34821 m0 *1 305.46,5213.3
X$34821 \$18 \$16077 \$16076 VSS INVR06
* cell instance $34824 r180 *1 369.26,5213.3
X$34824 \$18 \$15481 \$15473 VSS INVR02
* cell instance $34826 m0 *1 369.27,5213.3
X$34826 \$18 \$14456 \$16081 VSS INVR02
* cell instance $34827 r180 *1 407.07,5213.3
X$34827 \$13850 \$15027 \$18 \$15618 VSS OR2101
* cell instance $34830 m0 *1 419.65,5213.3
X$34830 \$18 \$15621 \$14578 VSS INVR02
* cell instance $34831 r180 *1 461.65,5213.3
X$34831 \$18 \$13061 \$15478 \$15475 VSS AND201
* cell instance $34833 m0 *1 464.28,5213.3
X$34833 \$16084 \$16086 \$18 \$16085 VSS OR2101
* cell instance $34836 m0 *1 497.88,5213.3
X$34836 \$18 \$16407 \$15034 VSS INVR06
* cell instance $34838 m0 *1 530.66,5213.3
X$34838 \$18 \$15626 \$14456 \$15475 VSS AND201
* cell instance $34841 m0 *1 560.66,5213.3
X$34841 \$18 \$15041 \$14456 \$13848 VSS AND201
* cell instance $34844 r180 *1 631.69,5213.3
X$34844 \$15040 \$18 \$13848 \$14456 VSS NOR201
* cell instance $34845 r180 *1 648.49,5213.3
X$34845 \$18 \$15627 \$16088 VSS INVR02
* cell instance $34848 r180 *1 686.42,5213.3
X$34848 \$13852 \$18 \$16090 VSS INVR05
* cell instance $34849 m0 *1 686.42,5213.3
X$34849 \$18 \$15805 \$14464 \$15050 VSS AND201
* cell instance $34850 m0 *1 711.62,5213.3
X$34850 \$18 \$15498 \$15629 VSS INVR03
* cell instance $34851 m0 *1 728.47,5213.3
X$34851 \$18 \$16091 \$15635 VSS INVR02
* cell instance $34852 m0 *1 745.27,5213.3
X$34852 \$18 \$15628 \$16094 VSS INVR02
* cell instance $34853 r180 *1 774.67,5213.3
X$34853 \$15491 \$18 \$15630 VSS INVR01
* cell instance $34855 m0 *1 779.68,5213.3
X$34855 \$18 \$14906 \$13539 VSS INVR02
* cell instance $34859 m0 *1 817.88,5213.3
X$34859 \$18 \$15936 \$15934 VSS INVR02
* cell instance $34863 r180 *1 863.13,5213.3
X$34863 \$18 \$15934 \$16090 VSS INVR02
* cell instance $34865 m0 *1 863.13,5213.3
X$34865 \$18 \$16283 \$15936 VSS INVR02
* cell instance $34869 m0 *1 1098.41,5213.3
X$34869 \$18 \$16106 \$15941 VSS INVR03
* cell instance $34872 m0 *1 1131.93,5213.3
X$34872 \$11152 \$15652 \$18 \$16109 VSS OR2101
* cell instance $34878 m0 *1 1234.1,5213.3
X$34878 \$18 \$15944 \$15064 VSS INVR03
* cell instance $34880 m0 *1 1253,5213.3
X$34880 \$18 \$11089 \$16111 VSS INVR02
* cell instance $34884 m0 *1 1291.26,5213.3
X$34884 \$18 \$16112 \$15512 VSS INVR03
* cell instance $34888 m0 *1 1320.66,5213.3
X$34888 \$18 \$15652 \$15944 VSS INVR02
* cell instance $34891 m0 *1 1344,5213.3
X$34891 \$16112 \$18 \$12421 VSS INVR05
* cell instance $34893 r180 *1 1389.76,5213.3
X$34893 \$16062 \$16118 \$16117 \$18 VSS NND201
* cell instance $34897 r180 *1 1412.51,5213.3
X$34897 \$18 \$15947 \$16118 VSS INVR02
* cell instance $34898 r180 *1 1429.31,5213.3
X$34898 \$18 \$13747 \$16119 VSS INVR03
* cell instance $34899 m0 *1 1429.31,5213.3
X$34899 \$18 \$16120 \$16121 VSS INVR03
* cell instance $34901 r180 *1 1468.59,5213.3
X$34901 \$18 \$15515 \$15947 VSS INVR02
* cell instance $34903 m0 *1 1469.28,5213.3
X$34903 \$15949 \$18 \$15947 VSS INVR01
* cell instance $34904 r180 *1 1498.69,5213.3
X$34904 \$18 \$16292 \$16122 VSS INVR02
* cell instance $34906 m0 *1 1504.03,5213.3
X$34906 \$18 \$16124 \$15949 \$14065 VSS AND201
* cell instance $34910 m0 *1 1541,5213.3
X$34910 \$18 \$16126 \$16125 \$14065 VSS AND201
* cell instance $34912 m0 *1 1566.21,5213.3
X$34912 \$16127 \$16578 \$18 \$16124 VSS OR2101
* cell instance $34913 r180 *1 1608.21,5213.3
X$34913 \$16417 \$16416 \$18 \$16126 VSS OR2101
* cell instance $34915 m0 *1 1610.56,5213.3
X$34915 \$18 \$16131 \$16130 VSS INVR06
* cell instance $34916 r180 *1 1665.16,5213.3
X$34916 \$18 \$16127 \$16133 \$13571 VSS AND201
* cell instance $34917 m0 *1 1665.16,5213.3
X$34917 \$18 \$16131 \$16133 VSS INVR02
* cell instance $34921 r180 *1 1772.66,5213.3
X$34921 \$18 \$12037 \$16137 VSS INVR06
* cell instance $34922 r180 *1 1790.06,5213.3
X$34922 \$18 \$16139 \$16138 VSS INVR02
* cell instance $34925 m0 *1 1803.26,5213.3
X$34925 \$18 \$16140 \$15953 VSS INVR02
* cell instance $34929 m0 *1 1833.26,5213.3
X$34929 \$18 \$15079 \$16140 VSS INVR02
* cell instance $34933 m0 *1 1863.26,5213.3
X$34933 \$18 \$15079 \$14625 VSS INVR02
* cell instance $34938 m0 *1 1893.26,5213.3
X$34938 \$18 \$5120 \$15373 VSS INVR06
* cell instance $34944 r180 *1 1978.52,5213.3
X$34944 \$12461 \$16735 \$18 \$15979 VSS OR2101
* cell instance $34945 m0 *1 1978.52,5213.3
X$34945 \$16145 \$18 \$16144 VSS INVR01
* cell instance $34949 m0 *1 2016.32,5213.3
X$34949 \$16148 \$18 \$16147 VSS INVR01
* cell instance $34953 m0 *1 2039.28,5213.3
X$34953 \$18 \$16253 \$11375 \$16149 VSS AND201
* cell instance $34954 m0 *1 2064.48,5213.3
X$34954 \$18 \$16253 \$16150 VSS INVR03
* cell instance $34957 r180 *1 2110.68,5213.3
X$34957 \$18 \$15665 \$16151 VSS INVR03
* cell instance $34958 r180 *1 2131.96,5213.3
X$34958 \$12461 \$16149 \$18 \$14213 VSS OR2101
* cell instance $34959 m0 *1 2131.96,5213.3
X$34959 \$16155 \$18 \$16156 \$15821 \$10222 VSS ADNR01
* cell instance $34960 m0 *1 2157.16,5213.3
X$34960 \$18 \$16157 \$8187 VSS INVR06
* cell instance $34963 r180 *1 2236.05,5213.3
X$34963 \$13435 \$15966 \$16158 \$10061 \$16298 \$18 VSS AOI401
* cell instance $34964 r180 *1 2257.06,5213.3
X$34964 \$14090 \$15377 \$18 \$15966 VSS OR2101
* cell instance $34965 m0 *1 2257.06,5213.3
X$34965 \$18 \$15827 \$16750 VSS INVR02
* cell instance $34966 m0 *1 2273.86,5213.3
X$34966 \$18 \$11884 \$15966 VSS INVR02
* cell instance $34970 m0 *1 2304.79,5213.3
X$34970 \$16298 \$18 \$15692 VSS INVR01
* cell instance $34971 m0 *1 2317.39,5213.3
X$34971 \$16162 \$18 \$15821 VSS INVR01
* cell instance $34972 m0 *1 2329.99,5213.3
X$34972 \$18 \$15828 \$14213 VSS INVR06
* cell instance $34973 m0 *1 2359.39,5213.3
X$34973 \$18 \$15537 \$16164 VSS INVR03
* cell instance $34977 r180 *1 2471.1,5213.3
X$34977 \$16166 \$18 \$15975 \$15678 \$10058 VSS AND301
* cell instance $34980 m0 *1 2482.71,5213.3
X$34980 \$18 \$11200 \$15827 VSS INVR02
* cell instance $34982 m0 *1 2499.51,5213.3
X$34982 \$18 \$11200 \$16170 VSS INVR02
* cell instance $34983 r180 *1 2538.72,5213.3
X$34983 \$16170 \$15975 \$18 \$16171 VSS OR2101
* cell instance $34985 m0 *1 2538.72,5213.3
X$34985 \$18 \$11899 \$15979 VSS INVR03
* cell instance $34993 m0 *1 2606.97,5213.3
X$34993 \$18 \$15828 \$15836 VSS INVR03
* cell instance $34996 r180 *1 2655.66,5213.3
X$34996 \$15979 \$15678 \$13446 \$18 \$8774 VSS OR3101
* cell instance $34999 r180 *1 2689.64,5213.3
X$34999 \$15836 \$16174 \$18 \$11886 VSS OR2101
* cell instance $35001 r180 *1 2727.39,5213.3
X$35001 \$15554 \$18 \$16174 \$16176 \$10058 VSS AND301
* cell instance $35002 m0 *1 2727.39,5213.3
X$35002 \$16178 \$14342 \$16179 \$15984 \$16180 \$18 VSS AND401
* cell instance $35005 r180 *1 2792.42,5213.3
X$35005 \$18 \$16265 \$15261 VSS INVR03
* cell instance $35007 r180 *1 2817.02,5213.3
X$35007 \$16171 \$16265 \$18 \$13366 VSS OR2101
* cell instance $35012 r180 *1 2852.42,5213.3
X$35012 \$18 \$15563 \$16176 VSS INVR03
* cell instance $35016 r180 *1 2892.47,5213.3
X$35016 \$18 \$15691 \$15257 \$15125 VSS AND201
* cell instance $35018 r180 *1 2922.48,5213.3
X$35018 \$11906 \$16187 \$18 \$16189 VSS OR2101
* cell instance $35020 m0 *1 2930.9,5213.3
X$35020 \$16192 \$18 \$15383 VSS INVR05
* cell instance $35021 r180 *1 2974.49,5213.3
X$35021 \$18 \$14483 \$16189 VSS INVR03
* cell instance $35023 m0 *1 2974.49,5213.3
X$35023 \$18 \$14509 \$16194 VSS INVR03
* cell instance $35024 m0 *1 2992.36,5213.3
X$35024 \$18 \$15841 \$16320 VSS INVR04
* cell instance $35027 m0 *1 3015.61,5213.3
X$35027 \$18 \$15989 \$16195 VSS INVR04
* cell instance $35028 m0 *1 3036.61,5213.3
X$35028 \$18 \$15990 \$16195 VSS INVR03
* cell instance $35029 m0 *1 3053.41,5213.3
X$35029 \$18 \$16196 \$15990 VSS INVR02
* cell instance $35030 m0 *1 3070.21,5213.3
X$35030 \$18 \$16197 \$14113 VSS INVR03
* cell instance $35031 r180 *1 3112.21,5213.3
X$35031 \$18 \$16199 \$16325 \$15125 VSS AND201
* cell instance $35033 r180 *1 3140.04,5213.3
X$35033 \$11906 \$18 \$16201 VSS INVR05
* cell instance $35035 r180 *1 3174.3,5213.3
X$35035 \$18 \$11390 \$16202 VSS INVR06
* cell instance $35037 r180 *1 3196.49,5213.3
X$35037 \$18 \$16203 \$15699 VSS INVR02
* cell instance $35039 r180 *1 3213.29,5213.3
X$35039 \$18 \$16204 \$15994 VSS INVR02
* cell instance $35042 r180 *1 3254.81,5213.3
X$35042 \$16202 \$18 \$15703 VSS INVR05
* cell instance $35043 m0 *1 3254.81,5213.3
X$35043 \$18 \$13139 \$15136 VSS INVR06
* cell instance $35045 r180 *1 3322.02,5213.3
X$35045 \$16328 \$18 \$9937 \$14125 VSS NOR201
* cell instance $35048 m0 *1 3333.49,5213.3
X$35048 \$18 \$15702 \$15703 VSS INVR03
* cell instance $35052 r180 *1 3392.89,5213.3
X$35052 \$18 \$16210 \$16450 VSS INVR06
* cell instance $35054 m0 *1 3392.89,5213.3
X$35054 \$16211 \$18 \$15852 VSS INVR05
* cell instance $35057 r180 *1 3451.35,5213.3
X$35057 \$15577 \$16212 \$15275 \$18 VSS NND201
* cell instance $35238 r180 *1 4987.47,5213.3
X$35238 \$8743 \$14135 \$15152 \$I331401 \$16213 \$18 VSS DFCL11
* cell instance $35249 m0 *1 5054.33,5213.3
X$35249 \$18 \$16215 \$16216 VSS INVR03
* cell instance $35413 m0 *1 6370.5,5213.3
X$35413 \$18 \$16218 \$16217 \$15153 VSS AND201
* cell instance $35419 r180 *1 6461.6,5213.3
X$35419 \$16219 \$18 \$16000 \$16218 VSS NOR201
* cell instance $35420 m0 *1 6461.61,5213.3
X$35420 \$18 \$15154 \$15160 VSS INVR02
* cell instance $35426 m0 *1 6518.78,5213.3
X$35426 \$18 \$15583 \$16222 VSS INVR02
* cell instance $35430 m0 *1 6550.1,5213.3
X$35430 \$15715 \$18 \$16222 VSS INVR05
* cell instance $35433 r180 *1 6607.28,5213.3
X$35433 \$18 \$16000 \$13657 \$16223 VSS AND201
* cell instance $35436 m0 *1 6617.66,5213.3
X$35436 \$15717 \$18 \$16006 \$15716 VSS NOR201
* cell instance $35439 r180 *1 6686.83,5213.3
X$35439 \$18 \$16006 \$13657 \$16008 VSS AND201
* cell instance $35440 m0 *1 6686.84,5213.3
X$35440 \$18 \$15859 \$13657 \$15167 VSS AND201
* cell instance $35444 r180 *1 6749.14,5213.3
X$35444 \$18 \$16008 \$16010 \$16224 VSS AND201
* cell instance $35446 r180 *1 6772.03,5213.3
X$35446 \$16010 \$16225 \$16227 \$18 VSS NND201
* cell instance $35448 m0 *1 6772.03,5213.3
X$35448 \$18 \$16227 \$15715 VSS INVR06
* cell instance $35449 m0 *1 6801.43,5213.3
X$35449 \$18 \$15718 \$16229 VSS INVR02
* cell instance $35450 m0 *1 6818.23,5213.3
X$35450 \$18 \$16229 \$16228 VSS INVR02
* cell instance $35461 r180 *1 6923.32,5213.3
X$35461 \$18 \$14555 \$16671 VSS INVR02
* cell instance $35710 m0 *1 37.77,4503.7
X$35710 \$18 \$11559 \$11814 VSS INVR03
* cell instance $35714 m0 *1 80.62,4503.7
X$35714 \$18 \$11814 \$11563 VSS INVR03
* cell instance $35726 m0 *1 265.66,4503.7
X$35726 \$18 \$11818 \$11817 VSS INVR03
* cell instance $35727 m0 *1 282.46,4503.7
X$35727 \$18 \$9424 \$11820 VSS INVR03
* cell instance $35731 m0 *1 313.32,4503.7
X$35731 \$18 \$11622 \$11327 VSS INVR02
* cell instance $35732 r180 *1 346.92,4503.7
X$35732 \$18 \$11334 \$11822 VSS INVR02
* cell instance $35733 m0 *1 346.92,4503.7
X$35733 \$18 \$11327 \$6777 VSS INVR03
* cell instance $35734 r180 *1 388.93,4503.7
X$35734 \$11116 \$18 \$6777 \$9654 \$9300 VSS ADNR01
* cell instance $35736 r180 *1 410.82,4503.7
X$35736 \$18 \$11826 \$10568 VSS INVR03
* cell instance $35738 m0 *1 410.82,4503.7
X$35738 \$10407 \$9998 \$12144 \$18 VSS NND201
* cell instance $35739 m0 *1 427.62,4503.7
X$35739 \$18 \$11679 \$12002 VSS INVR02
* cell instance $35740 r180 *1 461.22,4503.7
X$35740 \$18 \$12002 \$9429 VSS INVR03
* cell instance $35741 m0 *1 461.22,4503.7
X$35741 \$18 \$10000 \$11827 VSS INVR03
* cell instance $35745 r180 *1 519.6,4503.7
X$35745 \$11829 \$11622 \$18 \$11136 VSS OR2101
* cell instance $35747 r180 *1 549.58,4503.7
X$35747 \$18 \$11683 \$10805 \$11829 VSS AND201
* cell instance $35748 m0 *1 550.48,4503.7
X$35748 \$18 \$11565 \$11830 VSS INVR03
* cell instance $35749 r180 *1 592.48,4503.7
X$35749 \$18 \$11831 \$11829 \$12149 VSS AND201
* cell instance $35752 m0 *1 605.19,4503.7
X$35752 \$11830 \$11685 \$18 \$11829 VSS OR2101
* cell instance $35755 m0 *1 632.15,4503.7
X$35755 \$18 \$11685 \$11568 VSS INVR02
* cell instance $35756 m0 *1 648.99,4503.7
X$35756 \$18 \$11568 \$11835 VSS INVR02
* cell instance $35759 m0 *1 672.01,4503.7
X$35759 \$18 \$11835 \$11679 VSS INVR02
* cell instance $35760 m0 *1 690.01,4503.7
X$35760 \$11835 \$10803 \$11687 \$12266 \$10014 \$18 VSS AND401
* cell instance $35763 r180 *1 747.88,4503.7
X$35763 \$18 \$11838 \$10003 VSS INVR03
* cell instance $35765 m0 *1 747.88,4503.7
X$35765 \$18 \$11136 \$10805 VSS INVR06
* cell instance $35768 m0 *1 783.68,4503.7
X$35768 \$18 \$3880 \$9452 VSS INVR02
* cell instance $35771 m0 *1 807.77,4503.7
X$35771 \$18 \$12006 \$11691 \$11841 VSS AND201
* cell instance $35773 m0 *1 832.97,4503.7
X$35773 \$18 \$12006 \$12027 VSS INVR02
* cell instance $35774 m0 *1 849.77,4503.7
X$35774 \$18 \$11842 \$11571 VSS INVR02
* cell instance $35775 r180 *1 883.37,4503.7
X$35775 \$18 \$12155 \$11842 VSS INVR03
* cell instance $35776 m0 *1 883.37,4503.7
X$35776 \$18 \$11843 \$12028 VSS INVR02
* cell instance $35778 m0 *1 905.63,4503.7
X$35778 \$18 \$11571 \$11838 VSS INVR03
* cell instance $35783 m0 *1 935.61,4503.7
X$35783 \$18 \$11692 \$11139 VSS INVR06
* cell instance $35784 m0 *1 965.02,4503.7
X$35784 \$18 \$11561 \$11692 VSS INVR06
* cell instance $35790 m0 *1 1029.82,4503.7
X$35790 \$11848 \$18 \$7339 VSS INVR05
* cell instance $35795 m0 *1 1071.01,4503.7
X$35795 \$18 \$11849 \$10320 VSS INVR03
* cell instance $35799 m0 *1 1101.01,4503.7
X$35799 \$18 \$10587 \$11144 VSS INVR02
* cell instance $35801 r180 *1 1134.61,4503.7
X$35801 \$18 \$11142 \$11851 VSS INVR03
* cell instance $35804 r180 *1 1167.66,4503.7
X$35804 \$18 \$10208 \$11150 VSS INVR02
* cell instance $35805 m0 *1 1168.26,4503.7
X$35805 \$18 \$11695 \$11852 VSS INVR06
* cell instance $35806 m0 *1 1198.09,4503.7
X$35806 \$18 \$11696 \$12008 VSS INVR03
* cell instance $35808 m0 *1 1216.99,4503.7
X$35808 \$18 \$11853 \$12008 VSS INVR06
* cell instance $35810 m0 *1 1254.89,4503.7
X$35810 \$18 \$11697 \$10592 VSS INVR02
* cell instance $35815 m0 *1 1298.32,4503.7
X$35815 \$11697 \$18 \$8844 VSS INVR05
* cell instance $35817 m0 *1 1326.06,4503.7
X$35817 \$18 \$11641 \$11855 VSS INVR02
* cell instance $35818 m0 *1 1342.86,4503.7
X$35818 \$18 \$11856 \$11641 VSS INVR02
* cell instance $35820 m0 *1 1360.8,4503.7
X$35820 \$18 \$11700 \$11855 VSS INVR06
* cell instance $35825 m0 *1 1435.44,4503.7
X$35825 \$11859 \$11860 \$18 \$11702 VSS OR2101
* cell instance $35835 m0 *1 1521.98,4503.7
X$35835 \$18 \$9790 \$11119 VSS INVR06
* cell instance $35836 r180 *1 1580.78,4503.7
X$35836 \$18 \$7886 \$11358 VSS INVR06
* cell instance $35838 r180 *1 1618.98,4503.7
X$35838 \$18 \$11159 \$10043 VSS INVR06
* cell instance $35841 m0 *1 1632.25,4503.7
X$35841 \$18 \$11164 \$11867 VSS INVR02
* cell instance $35849 r180 *1 1705.8,4503.7
X$35849 \$18 \$11705 \$11706 \$11869 VSS AND201
* cell instance $35852 r180 *1 1736.27,4503.7
X$35852 \$18 \$11868 \$11869 \$11870 VSS AND201
* cell instance $35853 r180 *1 1753.07,4503.7
X$35853 \$18 \$10820 \$11154 VSS INVR03
* cell instance $35868 r180 *1 1982.05,4503.7
X$35868 \$18 \$11873 \$10825 \$10637 VSS AND201
* cell instance $35871 r180 *1 2011.1,4503.7
X$35871 \$18 \$11874 \$10609 \$11185 VSS AND201
* cell instance $35872 m0 *1 2011.1,4503.7
X$35872 \$18 \$11170 \$11160 VSS INVR02
* cell instance $35881 m0 *1 2093,4503.7
X$35881 \$11711 \$18 \$11876 VSS INVR01
* cell instance $35886 m0 *1 2119.78,4503.7
X$35886 \$11711 \$11878 \$18 \$11103 VSS OR2101
* cell instance $35889 r180 *1 2173.94,4503.7
X$35889 \$11103 \$18 \$11179 VSS INVR05
* cell instance $35893 r180 *1 2207.93,4503.7
X$35893 \$11715 \$11178 \$18 \$11876 VSS OR2101
* cell instance $35897 m0 *1 2247.83,4503.7
X$35897 \$18 \$10618 \$11183 VSS INVR03
* cell instance $35898 m0 *1 2264.63,4503.7
X$35898 \$18 \$11183 \$11884 VSS INVR03
* cell instance $35899 m0 *1 2281.43,4503.7
X$35899 \$11718 \$18 \$7559 VSS INVR05
* cell instance $35902 m0 *1 2310.14,4503.7
X$35902 \$18 \$11885 \$11718 VSS INVR06
* cell instance $35904 r180 *1 2370.35,4503.7
X$35904 \$11887 \$11720 \$18 \$11886 VSS OR2101
* cell instance $35908 m0 *1 2376.81,4503.7
X$35908 \$18 \$11889 \$11888 \$10607 VSS AND201
* cell instance $35910 r180 *1 2421.64,4503.7
X$35910 \$18 \$11721 \$11890 VSS INVR03
* cell instance $35914 r180 *1 2464.78,4503.7
X$35914 \$18 \$11721 \$8215 \$10620 VSS AND201
* cell instance $35915 r180 *1 2531.99,4503.7
X$35915 \$11024 \$11184 \$10841 \$12454 \$11724 \$11892 \$7071 \$12044 \$18 VSS
+ OR7101
* cell instance $35916 m0 *1 2532,4503.7
X$35916 \$11727 \$18 \$11853 VSS INVR05
* cell instance $35919 r180 *1 2592,4503.7
X$35919 \$18 \$11197 \$11194 \$9691 VSS AND201
* cell instance $35921 r180 *1 2617.42,4503.7
X$35921 \$18 \$11897 \$11896 VSS INVR03
* cell instance $35923 m0 *1 2619.51,4503.7
X$35923 \$18 \$11899 \$11201 VSS INVR06
* cell instance $35924 m0 *1 2650.7,4503.7
X$35924 \$18 \$7572 \$11900 VSS INVR02
* cell instance $35929 m0 *1 2675.4,4503.7
X$35929 \$18 \$10630 \$11700 VSS INVR06
* cell instance $35934 r180 *1 2759.83,4503.7
X$35934 \$11206 \$11903 \$18 \$11103 VSS OR2101
* cell instance $35937 r180 *1 2789.83,4503.7
X$35937 \$8212 \$11672 \$18 \$11906 VSS OR2101
* cell instance $35943 m0 *1 2805.44,4503.7
X$35943 \$18 \$8212 \$11193 VSS INVR06
* cell instance $35944 m0 *1 2834.84,4503.7
X$35944 \$18 \$11909 \$11906 VSS INVR03
* cell instance $35945 r180 *1 2868.44,4503.7
X$35945 \$18 \$11672 \$11211 VSS INVR02
* cell instance $35946 m0 *1 2868.44,4503.7
X$35946 \$11196 \$11913 \$11914 \$11224 \$11216 \$18 VSS AOI401
* cell instance $35948 m0 *1 2920.3,4503.7
X$35948 \$11196 \$18 \$12324 VSS INVR05
* cell instance $35951 r180 *1 2966.44,4503.7
X$35951 \$18 \$11225 \$11206 VSS INVR02
* cell instance $35952 m0 *1 2966.44,4503.7
X$35952 \$11906 \$18 \$11915 VSS INVR05
* cell instance $35953 m0 *1 2991.64,4503.7
X$35953 \$10060 \$18 \$11916 VSS INVR05
* cell instance $35960 m0 *1 3055.26,4503.7
X$35960 \$18 \$10666 \$9327 VSS INVR06
* cell instance $35961 m0 *1 3084.66,4503.7
X$35961 \$18 \$11737 \$11225 VSS INVR06
* cell instance $35962 m0 *1 3114.06,4503.7
X$35962 \$11921 \$8617 \$11199 \$18 VSS NND201
* cell instance $35963 m0 *1 3130.86,4503.7
X$35963 \$12184 \$11921 \$11196 \$18 VSS NND201
* cell instance $35964 m0 *1 3147.67,4503.7
X$35964 \$18 \$11392 \$12185 VSS INVR02
* cell instance $35965 m0 *1 3164.47,4503.7
X$35965 \$18 \$9220 \$10648 VSS INVR03
* cell instance $35966 m0 *1 3181.27,4503.7
X$35966 \$18 \$11923 \$11738 VSS INVR06
* cell instance $35970 m0 *1 3234.83,4503.7
X$35970 \$18 \$11738 \$11924 VSS INVR03
* cell instance $35972 m0 *1 3254.66,4503.7
X$35972 \$18 \$11925 \$8889 \$10074 VSS AND201
* cell instance $35976 m0 *1 3291.56,4503.7
X$35976 \$11215 \$12187 \$18 \$10086 VSS OR2101
* cell instance $35979 r180 *1 3342.57,4503.7
X$35979 \$10655 \$9030 \$18 \$11928 VSS OR2101
* cell instance $35982 m0 *1 3356.38,4503.7
X$35982 \$18 \$11229 \$10650 VSS INVR03
* cell instance $35985 r180 *1 3398.39,4503.7
X$35985 \$18 \$11741 \$10086 VSS INVR03
* cell instance $35989 m0 *1 3413.18,4503.7
X$35989 \$18 \$11228 \$7719 VSS INVR06
* cell instance $36015 m0 *1 3632.41,4503.7
X$36015 \$18 \$11932 \$11931 VSS INVR06
* cell instance $36079 m0 *1 4247.97,4503.7
X$36079 \$18 \$10669 \$11400 VSS INVR03
* cell instance $36084 m0 *1 4287.07,4503.7
X$36084 \$7941 \$18 \$11937 VSS INVR05
* cell instance $36098 m0 *1 4417.56,4503.7
X$36098 \$18 \$11938 \$11937 VSS INVR03
* cell instance $36110 m0 *1 4515.85,4503.7
X$36110 \$18 \$5791 \$11940 VSS INVR03
* cell instance $36117 m0 *1 4570.44,4503.7
X$36117 \$18 \$11940 \$11237 VSS INVR03
* cell instance $36127 r180 *1 4665,4503.7
X$36127 \$18 \$11944 \$11943 VSS INVR02
* cell instance $36132 r180 *1 4709.36,4503.7
X$36132 \$18 \$11241 \$11944 VSS INVR02
* cell instance $36138 m0 *1 4735.95,4503.7
X$36138 \$11945 \$11245 \$18 \$11944 VSS OR2101
* cell instance $36141 m0 *1 4770.16,4503.7
X$36141 \$18 \$11244 \$11947 VSS INVR02
* cell instance $36152 m0 *1 4852.76,4503.7
X$36152 \$18 \$11948 \$11593 VSS INVR02
* cell instance $36153 m0 *1 4869.56,4503.7
X$36153 \$11947 \$12189 \$18 \$11247 VSS OR2101
* cell instance $36157 m0 *1 4911.74,4503.7
X$36157 \$11950 \$18 \$11593 VSS INVR01
* cell instance $36161 m0 *1 4935.96,4503.7
X$36161 \$11594 \$12015 \$18 \$11950 VSS OR2101
* cell instance $36165 m0 *1 4964.35,4503.7
X$36165 \$18 \$12015 \$11248 VSS INVR02
* cell instance $36168 m0 *1 4983.69,4503.7
X$36168 \$18 \$11947 \$11953 VSS INVR03
* cell instance $36174 m0 *1 5041.4,4503.7
X$36174 \$18 \$11953 \$11251 VSS INVR02
* cell instance $36183 m0 *1 5123.93,4503.7
X$36183 \$18 \$11932 \$11955 VSS INVR02
* cell instance $36187 m0 *1 5147.81,4503.7
X$36187 \$18 \$11956 \$11406 VSS INVR02
* cell instance $36189 r180 *1 5181.42,4503.7
X$36189 \$11595 \$10102 \$11957 \$18 VSS NND201
* cell instance $36197 m0 *1 5237.82,4503.7
X$36197 \$18 \$11750 \$11958 VSS INVR03
* cell instance $36199 m0 *1 5256.62,4503.7
X$36199 \$18 \$11959 \$11750 VSS INVR02
* cell instance $36200 r180 *1 5374.22,4503.7
X$36200 \$8743 \$11596 \$11261 \$I331403 \$11959 \$18 VSS DFCL11
* cell instance $36210 m0 *1 5442.9,4503.7
X$36210 \$8743 \$11599 \$11266 \$I331447 \$11267 \$18 VSS DFCL11
* cell instance $36221 m0 *1 5619.34,4503.7
X$36221 \$8743 \$11600 \$11270 \$I331458 \$11755 \$18 VSS DFCL11
* cell instance $36225 m0 *1 5732.86,4503.7
X$36225 \$18 \$11755 \$11756 VSS INVR02
* cell instance $36228 m0 *1 5762.28,4503.7
X$36228 \$18 \$11756 \$11964 VSS INVR03
* cell instance $36229 m0 *1 5780.82,4503.7
X$36229 \$18 \$11964 \$11276 VSS INVR03
* cell instance $36231 m0 *1 5797.62,4503.7
X$36231 \$18 \$11966 \$11274 VSS INVR06
* cell instance $36232 r180 *1 5927.82,4503.7
X$36232 \$8743 \$11600 \$11968 \$I331400 \$11275 \$18 VSS DFCL11
* cell instance $36233 r180 *1 5945.23,4503.7
X$36233 \$18 \$11601 \$11968 VSS INVR03
* cell instance $36234 m0 *1 5945.23,4503.7
X$36234 \$18 \$11264 \$9136 VSS INVR02
* cell instance $36235 m0 *1 5962.19,4503.7
X$36235 \$18 \$11969 \$12009 VSS INVR02
* cell instance $36236 m0 *1 5978.99,4503.7
X$36236 \$18 \$12009 \$11601 VSS INVR02
* cell instance $36237 m0 *1 5995.8,4503.7
X$36237 \$18 \$11971 \$11972 VSS INVR03
* cell instance $36240 r180 *1 6051,4503.7
X$36240 \$18 \$11973 \$10101 \$11975 VSS AND201
* cell instance $36244 m0 *1 6058.5,4503.7
X$36244 \$18 \$11281 \$11282 VSS INVR02
* cell instance $36250 m0 *1 6099,4503.7
X$36250 \$18 \$11602 \$11418 VSS INVR02
* cell instance $36252 m0 *1 6115.8,4503.7
X$36252 \$18 \$12068 \$11602 VSS INVR02
* cell instance $36257 m0 *1 6159,4503.7
X$36257 \$18 \$11420 \$12365 VSS INVR03
* cell instance $36266 m0 *1 6231.57,4503.7
X$36266 \$18 \$11623 \$11418 \$9956 VSS AND201
* cell instance $36269 m0 *1 6262.77,4503.7
X$36269 \$18 \$11426 \$11966 \$9956 VSS AND201
* cell instance $36271 m0 *1 6287.98,4503.7
X$36271 \$18 \$11618 \$9576 \$9956 VSS AND201
* cell instance $36273 m0 *1 6317.98,4503.7
X$36273 \$18 \$11264 \$11980 VSS INVR03
* cell instance $36279 m0 *1 6364.85,4503.7
X$36279 \$12005 \$18 \$11623 \$11981 VSS NOR201
* cell instance $36281 m0 *1 6401.49,4503.7
X$36281 \$18 \$12005 \$12775 VSS INVR03
* cell instance $36283 m0 *1 6418.29,4503.7
X$36283 \$18 \$11614 \$11982 VSS INVR03
* cell instance $36285 m0 *1 6443.16,4503.7
X$36285 \$11285 \$18 \$11618 \$11289 VSS NOR201
* cell instance $36286 m0 *1 6476.76,4503.7
X$36286 \$11614 \$18 \$11426 \$11984 VSS NOR201
* cell instance $36291 m0 *1 6542.47,4503.7
X$36291 \$18 \$11985 \$11986 VSS INVR03
* cell instance $36296 m0 *1 6588.67,4503.7
X$36296 \$18 \$11984 \$11292 \$11290 VSS AND201
* cell instance $36307 m0 *1 6686.41,4503.7
X$36307 \$18 \$11774 \$11292 VSS INVR03
* cell instance $36308 m0 *1 6703.21,4503.7
X$36308 \$18 \$11775 \$11774 VSS INVR02
* cell instance $36311 m0 *1 6736.66,4503.7
X$36311 \$11776 \$18 \$11986 VSS INVR05
* cell instance $36378 m0 *1 7279.73,4503.7
X$36378 \$18 \$11991 \$11776 VSS INVR06
* cell instance $36420 m0 *1 7638.15,4503.7
X$36420 \$11607 \$18 \$11291 VSS INVR05
* cell instance $36544 m0 *1 8630.36,4503.7
X$36544 \$18 \$11780 \$11431 VSS INVR03
* cell instance $36552 m0 *1 8700.24,4503.7
X$36552 \$18 \$11607 \$11994 VSS INVR03
* cell instance $36561 m0 *1 8768.79,4503.7
X$36561 \$18 \$11429 \$11995 VSS INVR03
* cell instance $36569 m0 *1 8829.92,4503.7
X$36569 \$18 \$11302 \$11608 VSS INVR02
* cell instance $36573 m0 *1 8867.38,4503.7
X$36573 \$18 \$11995 \$11784 VSS INVR02
* cell instance $36576 m0 *1 59.22,5922.9
X$36576 \$18 \$18812 \$18903 VSS INVR02
* cell instance $36580 m0 *1 192.27,5922.9
X$36580 \$18 \$18904 \$18580 VSS INVR03
* cell instance $36586 m0 *1 242.06,5922.9
X$36586 \$18904 \$18674 \$923 \$19013 \$16987 \$18 VSS AND401
* cell instance $36588 m0 *1 284.67,5922.9
X$36588 \$16283 \$18 \$18909 VSS INVR05
* cell instance $36589 r180 *1 344.08,5922.9
X$36589 \$18911 \$18 \$19058 \$18580 VSS NOR201
* cell instance $36592 r180 *1 383.94,5922.9
X$36592 \$18 \$19014 \$18037 VSS INVR06
* cell instance $36593 m0 *1 484.75,5922.9
X$36593 \$18 \$18917 \$18918 VSS INVR02
* cell instance $36594 r180 *1 518.35,5922.9
X$36594 \$18 \$18919 \$18675 VSS INVR02
* cell instance $36596 m0 *1 526.99,5922.9
X$36596 \$18 \$18818 \$18921 VSS INVR02
* cell instance $36600 m0 *1 709.89,5922.9
X$36600 \$18 \$17797 \$18668 VSS INVR03
* cell instance $36603 m0 *1 742.74,5922.9
X$36603 \$18825 \$17959 \$18379 \$18 VSS NND201
* cell instance $36605 r180 *1 801.27,5922.9
X$36605 \$18926 \$18825 \$18381 \$18826 \$18681 \$18 VSS AND401
* cell instance $36607 m0 *1 801.28,5922.9
X$36607 \$18388 \$17689 \$18054 \$18998 \$15637 \$17613 \$18 VSS NND501
* cell instance $36608 m0 *1 851.68,5922.9
X$36608 \$18 \$18998 \$18929 VSS INVR02
* cell instance $36609 m0 *1 868.48,5922.9
X$36609 \$18931 \$18 \$17803 VSS INVR01
* cell instance $36611 m0 *1 884.44,5922.9
X$36611 \$18 \$18932 \$18933 VSS INVR02
* cell instance $36619 m0 *1 1142.4,5922.9
X$36619 \$18 \$17017 \$18940 VSS INVR03
* cell instance $36622 m0 *1 1163.58,5922.9
X$36622 \$18 \$18689 \$18839 VSS INVR02
* cell instance $36623 m0 *1 1180.38,5922.9
X$36623 \$18 \$18941 \$18942 VSS INVR02
* cell instance $36624 m0 *1 1197.18,5922.9
X$36624 \$18 \$18839 \$18762 VSS INVR03
* cell instance $36632 m0 *1 1260.18,5922.9
X$36632 \$18 \$18598 \$18601 VSS INVR02
* cell instance $36633 m0 *1 1276.98,5922.9
X$36633 \$18 \$18945 \$18843 VSS INVR02
* cell instance $36636 m0 *1 1304.81,5922.9
X$36636 \$18606 \$18947 \$18 \$18843 VSS OR2101
* cell instance $36638 m0 *1 1325.81,5922.9
X$36638 \$18949 \$18 \$18938 VSS INVR01
* cell instance $36640 m0 *1 1346.85,5922.9
X$36640 \$18949 \$18603 \$18 \$18606 VSS OR2101
* cell instance $36642 r180 *1 1389.46,5922.9
X$36642 \$18 \$18953 \$18938 VSS INVR03
* cell instance $36649 r180 *1 1444.66,5922.9
X$36649 \$18954 \$18693 \$18947 \$18 VSS NND201
* cell instance $36651 m0 *1 1453.52,5922.9
X$36651 \$18607 \$18 \$18695 VSS INVR01
* cell instance $36656 m0 *1 1584.14,5922.9
X$36656 \$18 \$18617 \$18616 \$17708 VSS AND201
* cell instance $36658 m0 *1 1609.34,5922.9
X$36658 \$18 \$18963 \$18412 VSS INVR02
* cell instance $36666 m0 *1 1684.22,5922.9
X$36666 \$18 \$18965 \$18966 VSS INVR03
* cell instance $36678 m0 *1 1863.4,5922.9
X$36678 \$18 \$18533 \$18971 VSS INVR02
* cell instance $36679 r180 *1 1897,5922.9
X$36679 \$18 \$18851 \$17717 VSS INVR03
* cell instance $36686 r180 *1 1953.01,5922.9
X$36686 \$18 \$18973 \$18851 VSS INVR02
* cell instance $36715 m0 *1 2249.73,5922.9
X$36715 \$18442 \$18975 \$18428 \$18 \$18854 VSS OR3101
* cell instance $36722 m0 *1 2324.62,5922.9
X$36722 \$18637 \$18 \$16608 VSS INVR01
* cell instance $36725 r180 *1 2368.54,5922.9
X$36725 \$18704 \$18854 \$18710 \$18 \$18433 VSS OR3101
* cell instance $36726 m0 *1 2369.14,5922.9
X$36726 \$15104 \$18638 \$18 \$18703 VSS OR2101
* cell instance $36745 r180 *1 2542.17,5922.9
X$36745 \$18706 \$18773 \$18982 \$18 VSS NND201
* cell instance $36747 m0 *1 2542.17,5922.9
X$36747 \$18982 \$18 \$18435 VSS INVR01
* cell instance $36759 r180 *1 2668.82,5922.9
X$36759 \$18 \$18983 \$8212 \$18642 VSS AND201
* cell instance $36770 m0 *1 2743.54,5922.9
X$36770 \$18 \$18985 \$18864 VSS INVR02
* cell instance $36771 m0 *1 2760.34,5922.9
X$36771 \$19031 \$18 \$18642 \$18641 VSS NOR201
* cell instance $36786 r180 *1 2913.26,5922.9
X$36786 \$18 \$18867 \$18986 VSS INVR03
* cell instance $36789 m0 *1 2923.84,5922.9
X$36789 \$18 \$18867 \$18451 VSS INVR02
* cell instance $36790 m0 *1 2942.44,5922.9
X$36790 \$18 \$18864 \$16644 VSS INVR03
* cell instance $36792 r180 *1 2976.04,5922.9
X$36792 \$18 \$18870 \$18867 VSS INVR02
* cell instance $36797 r180 *1 3030.12,5922.9
X$36797 \$18641 \$18870 \$18 \$16196 VSS OR2101
* cell instance $36926 m0 *1 4039.24,5922.9
X$36926 \$18 \$18989 \$18988 VSS INVR06
* cell instance $36927 m0 *1 4069.24,5922.9
X$36927 \$18 \$18871 \$18988 VSS INVR03
* cell instance $36928 r180 *1 4102.84,5922.9
X$36928 \$18 \$13627 \$18871 VSS INVR03
* cell instance $36929 m0 *1 4102.84,5922.9
X$36929 \$18 \$18653 \$18654 VSS INVR03
* cell instance $36934 m0 *1 4142.07,5922.9
X$36934 \$18 \$6064 \$18991 VSS INVR03
* cell instance $36938 m0 *1 4172.08,5922.9
X$36938 \$18 \$18993 \$18992 VSS INVR06
* cell instance $37529 m0 *1 39,6100.3
X$37529 \$18 \$18932 \$18903 VSS INVR04
* cell instance $37530 r180 *1 81,6100.3
X$37530 \$19367 \$19134 \$18 \$19362 VSS OR2101
* cell instance $37534 r180 *1 125.07,6100.3
X$37534 \$18 \$19362 \$19363 \$18358 VSS AND201
* cell instance $37535 r180 *1 164.58,6100.3
X$37535 \$19364 \$18904 \$19363 \$18 VSS XNR201
* cell instance $37538 r180 *1 208.8,6100.3
X$37538 \$19366 \$19426 \$19365 \$18 VSS XOR201
* cell instance $37540 r180 *1 242.25,6100.3
X$37540 \$18 \$19367 \$19014 \$18904 VSS AND201
* cell instance $37543 m0 *1 256.01,6100.3
X$37543 \$18 \$19368 \$19014 \$19138 VSS AND201
* cell instance $37547 m0 *1 289.06,6100.3
X$37547 \$19368 \$18673 \$18 \$19429 VSS OR2101
* cell instance $37550 m0 *1 364.66,6100.3
X$37550 \$18 \$19330 \$19517 VSS INVR02
* cell instance $37551 r180 *1 423.46,6100.3
X$37551 \$18911 \$18525 \$19330 \$18 VSS XOR201
* cell instance $37554 r180 *1 454.63,6100.3
X$37554 \$19433 \$19371 \$18 \$19374 VSS OR2101
* cell instance $37556 m0 *1 458.28,6100.3
X$37556 \$18 \$19371 \$19372 VSS INVR02
* cell instance $37561 m0 *1 495.69,6100.3
X$37561 \$18 \$5730 \$19373 VSS INVR02
* cell instance $37562 r180 *1 537.69,6100.3
X$37562 \$18 \$19374 \$19375 \$18922 VSS AND201
* cell instance $37568 m0 *1 769.29,6100.3
X$37568 \$19153 \$18922 \$19376 \$18 VSS NND201
* cell instance $37570 r180 *1 826.87,6100.3
X$37570 \$19379 \$19336 \$19378 \$19377 \$19524 \$18 VSS AND401
* cell instance $37571 m0 *1 826.87,6100.3
X$37571 \$19336 \$17959 \$19376 \$18 VSS NND201
* cell instance $37572 r180 *1 856.27,6100.3
X$37572 \$19161 \$18 \$17803 VSS INVR01
* cell instance $37573 r180 *1 869.47,6100.3
X$37573 \$19380 \$18 \$17803 VSS INVR01
* cell instance $37577 r180 *1 901.12,6100.3
X$37577 \$18 \$19171 \$19377 VSS INVR02
* cell instance $37582 m0 *1 1020.14,6100.3
X$37582 \$18 \$19449 \$19384 VSS INVR02
* cell instance $37587 m0 *1 1145.06,6100.3
X$37587 \$18 \$18940 \$19453 VSS INVR03
* cell instance $37588 r180 *1 1178.66,6100.3
X$37588 \$18 \$19341 \$19455 VSS INVR02
* cell instance $37589 r180 *1 1199.66,6100.3
X$37589 \$19453 \$19528 \$18 \$19278 VSS OR2101
* cell instance $37590 m0 *1 1199.66,6100.3
X$37590 \$18 \$11695 \$19341 VSS INVR02
* cell instance $37591 m0 *1 1217.5,6100.3
X$37591 \$18 \$18940 \$19179 VSS INVR03
* cell instance $37595 m0 *1 1293.91,6100.3
X$37595 \$18691 \$19390 \$18 \$19179 VSS OR2101
* cell instance $37596 m0 *1 1314.91,6100.3
X$37596 \$18 \$3227 \$19460 VSS INVR06
* cell instance $37597 r180 *1 1365.31,6100.3
X$37597 \$19183 \$19392 \$18 \$19179 VSS OR2101
* cell instance $37599 m0 *1 1367.17,6100.3
X$37599 \$18 \$19390 \$19464 VSS INVR02
* cell instance $37600 m0 *1 1383.98,6100.3
X$37600 \$18 \$19393 \$19464 VSS INVR06
* cell instance $37607 m0 *1 1456.59,6100.3
X$37607 \$18 \$19395 \$19394 VSS INVR02
* cell instance $37610 m0 *1 1476.11,6100.3
X$37610 \$18 \$19466 \$19395 VSS INVR02
* cell instance $37613 r180 *1 1535.3,6100.3
X$37613 \$19174 \$18 \$19468 VSS INVR05
* cell instance $37617 m0 *1 1541.82,6100.3
X$37617 \$18 \$16106 \$17024 VSS INVR06
* cell instance $37618 m0 *1 1571.22,6100.3
X$37618 \$18 \$19399 \$19471 VSS INVR03
* cell instance $37619 m0 *1 1588.02,6100.3
X$37619 \$18 \$19197 \$19194 \$17708 VSS AND201
* cell instance $37621 r180 *1 1633.13,6100.3
X$37621 \$18 \$19473 \$19401 VSS INVR02
* cell instance $37635 m0 *1 1730.54,6100.3
X$37635 \$18 \$19202 \$18965 VSS INVR02
* cell instance $37637 r180 *1 1764.14,6100.3
X$37637 \$18 \$19203 \$19190 VSS INVR02
* cell instance $37641 r180 *1 1805.67,6100.3
X$37641 \$18 \$19206 \$19205 VSS INVR03
* cell instance $37649 m0 *1 1858.16,6100.3
X$37649 \$18 \$19207 \$18849 VSS INVR03
* cell instance $37663 m0 *1 1979.25,6100.3
X$37663 \$18 \$18852 \$18533 VSS INVR03
* cell instance $37685 m0 *1 2157.16,6100.3
X$37685 \$18 \$19359 \$16157 VSS INVR06
* cell instance $37909 m0 *1 3965.3,6100.3
X$37909 \$18 \$6383 \$19477 VSS INVR03
* cell instance $37910 m0 *1 3982.1,6100.3
X$37910 \$18 \$19477 \$19503 VSS INVR03
* cell instance $37913 m0 *1 4012.1,6100.3
X$37913 \$19903 \$18 \$19503 VSS INVR05
* cell instance $37920 m0 *1 4072.11,6100.3
X$37920 \$18 \$12956 \$19478 VSS INVR03
* cell instance $37925 m0 *1 4114.53,6100.3
X$37925 \$18 \$19407 \$19478 VSS INVR06
* cell instance $37928 m0 *1 4154.25,6100.3
X$37928 \$18 \$14133 \$19480 VSS INVR03
* cell instance $37934 m0 *1 4212.9,6100.3
X$37934 \$18 \$19408 \$19482 VSS INVR03
* cell instance $37941 m0 *1 4258.81,6100.3
X$37941 \$18 \$19409 \$19480 VSS INVR06
* cell instance $37960 r180 *1 4451.75,6100.3
X$37960 \$18 \$19410 \$19484 VSS INVR06
* cell instance $37964 r180 *1 4487.67,6100.3
X$37964 \$18 \$14669 \$19484 VSS INVR03
* cell instance $38031 m0 *1 5008.01,6100.3
X$38031 \$18 \$19411 \$19412 VSS INVR06
* cell instance $38032 m0 *1 5037.41,6100.3
X$38032 \$18 \$19412 \$19221 VSS INVR06
* cell instance $38511 m0 *1 64.2,5745.5
X$38511 \$18 \$18356 \$18154 VSS INVR02
* cell instance $38515 m0 *1 102.52,5745.5
X$38515 \$18 \$16509 \$18460 VSS INVR03
* cell instance $38517 m0 *1 119.32,5745.5
X$38517 \$17805 \$18 \$18460 VSS INVR05
* cell instance $38520 m0 *1 157.72,5745.5
X$38520 \$18 \$17668 \$17668 VSS INVR02
* cell instance $38522 r180 *1 200.45,5745.5
X$38522 \$18 \$18025 \$17388 \$17254 VSS AND201
* cell instance $38523 m0 *1 200.45,5745.5
X$38523 \$18 \$17385 \$17386 VSS INVR03
* cell instance $38525 m0 *1 222.66,5745.5
X$38525 \$18361 \$18358 \$18360 \$18 VSS NND201
* cell instance $38527 m0 *1 239.46,5745.5
X$38527 \$18 \$923 \$18362 VSS INVR03
* cell instance $38528 m0 *1 256.27,5745.5
X$38528 \$18 \$18362 \$16987 VSS INVR03
* cell instance $38529 r180 *1 298.27,5745.5
X$38529 \$18 \$18364 \$16077 \$18032 VSS AND201
* cell instance $38532 m0 *1 310.87,5745.5
X$38532 \$18 \$16987 \$18032 VSS INVR02
* cell instance $38533 m0 *1 327.67,5745.5
X$38533 \$18 \$18162 \$17674 VSS INVR02
* cell instance $38536 m0 *1 362.18,5745.5
X$38536 \$18 \$18282 \$18366 \$16517 VSS AND201
* cell instance $38542 m0 *1 415.06,5745.5
X$38542 \$18 \$16987 \$18525 VSS INVR02
* cell instance $38546 m0 *1 438.87,5745.5
X$38546 \$18 \$18154 \$16994 VSS INVR03
* cell instance $38550 r180 *1 497.13,5745.5
X$38550 \$18282 \$18368 \$18 \$18369 VSS OR2101
* cell instance $38553 m0 *1 507.98,5745.5
X$38553 \$18 \$18046 \$16407 \$18041 VSS AND201
* cell instance $38555 r180 *1 567.51,5745.5
X$38555 \$18 \$18369 \$18373 \$16407 VSS AND201
* cell instance $38560 r180 *1 611.69,5745.5
X$38560 \$18 \$18526 \$16407 VSS INVR06
* cell instance $38561 m0 *1 611.69,5745.5
X$38561 \$18 \$16407 \$18466 VSS INVR03
* cell instance $38564 m0 *1 645.09,5745.5
X$38564 \$18 \$17306 \$18466 VSS INVR06
* cell instance $38567 m0 *1 687.77,5745.5
X$38567 \$18 \$18048 \$18375 VSS INVR02
* cell instance $38572 m0 *1 719.01,5745.5
X$38572 \$18 \$18375 \$18377 VSS INVR02
* cell instance $38574 m0 *1 737.93,5745.5
X$38574 \$18 \$18378 \$18379 VSS INVR02
* cell instance $38575 m0 *1 754.73,5745.5
X$38575 \$18381 \$17306 \$18377 \$18 VSS NND201
* cell instance $38577 m0 *1 776.27,5745.5
X$38577 \$18 \$18382 \$18383 VSS INVR02
* cell instance $38579 m0 *1 801.54,5745.5
X$38579 \$17519 \$17959 \$18377 \$18 VSS NND201
* cell instance $38590 m0 *1 899.02,5745.5
X$38590 \$18388 \$17306 \$18387 \$18 VSS NND201
* cell instance $38594 m0 *1 936.5,5745.5
X$38594 \$17397 \$18 \$18389 VSS INVR05
* cell instance $38597 r180 *1 991.11,5745.5
X$38597 \$18 \$17698 \$18391 VSS INVR03
* cell instance $38598 m0 *1 991.2,5745.5
X$38598 \$18 \$15502 \$18392 VSS INVR02
* cell instance $38607 m0 *1 1067.87,5745.5
X$38607 \$18 \$18055 \$18389 VSS INVR03
* cell instance $38609 m0 *1 1084.67,5745.5
X$38609 \$18 \$18053 \$18058 VSS INVR03
* cell instance $38612 m0 *1 1208.67,5745.5
X$38612 \$18 \$18058 \$18294 VSS INVR02
* cell instance $38615 m0 *1 1238.67,5745.5
X$38615 \$18 \$18397 \$18060 VSS INVR02
* cell instance $38621 r180 *1 1300.49,5745.5
X$38621 \$18297 \$18399 \$18398 \$18 VSS NND201
* cell instance $38622 r180 *1 1317.29,5745.5
X$38622 \$18400 \$14061 \$18401 \$18 VSS NND201
* cell instance $38624 m0 *1 1325.65,5745.5
X$38624 \$18401 \$18398 \$18 \$18062 VSS OR2101
* cell instance $38632 r180 *1 1421.54,5745.5
X$38632 \$18403 \$17709 \$18401 \$18 VSS NND201
* cell instance $38636 r180 *1 1444.69,5745.5
X$38636 \$18 \$18406 \$18077 VSS INVR02
* cell instance $38639 r180 *1 1474.53,5745.5
X$38639 \$18 \$18407 \$18406 VSS INVR02
* cell instance $38643 m0 *1 1584.57,5745.5
X$38643 \$18 \$18413 \$18412 \$17708 VSS AND201
* cell instance $38645 m0 *1 1613.77,5745.5
X$38645 \$18 \$17710 \$17713 VSS INVR02
* cell instance $38647 r180 *1 1664.97,5745.5
X$38647 \$18 \$18414 \$18101 \$16582 VSS AND201
* cell instance $38650 r180 *1 1691.63,5745.5
X$38650 \$18 \$18415 \$16582 \$17717 VSS AND201
* cell instance $38653 m0 *1 1705.33,5745.5
X$38653 \$18 \$18091 \$18416 VSS INVR02
* cell instance $38655 m0 *1 1722.14,5745.5
X$38655 \$18 \$18417 \$18087 VSS INVR02
* cell instance $38656 r180 *1 1765.29,5745.5
X$38656 \$18 \$18265 \$17828 \$16582 VSS AND201
* cell instance $38658 m0 *1 1765.3,5745.5
X$38658 \$18 \$18418 \$18419 VSS INVR03
* cell instance $38659 m0 *1 1782.1,5745.5
X$38659 \$18265 \$18418 \$18 \$18413 VSS OR2101
* cell instance $38668 m0 *1 1861.99,5745.5
X$38668 \$18 \$18095 \$18424 VSS INVR03
* cell instance $38669 m0 *1 1878.79,5745.5
X$38669 \$18099 \$18 \$18424 VSS INVR05
* cell instance $38670 m0 *1 1903.99,5745.5
X$38670 \$18 \$18533 \$18192 VSS INVR02
* cell instance $38675 m0 *1 1948.8,5745.5
X$38675 \$18 \$18100 \$18426 VSS INVR03
* cell instance $38699 m0 *1 2179.99,5745.5
X$38699 \$18 \$14633 \$13752 VSS INVR06
* cell instance $38702 r180 *1 2243.23,5745.5
X$38702 \$18430 \$18428 \$18 \$14633 VSS OR2101
* cell instance $38705 r180 *1 2284.5,5745.5
X$38705 \$18 \$18430 \$18432 \$15104 VSS AND201
* cell instance $38708 r180 *1 2309.29,5745.5
X$38708 \$18432 \$18 \$18109 VSS INVR01
* cell instance $38712 r180 *1 2353.05,5745.5
X$38712 \$18 \$18433 \$12044 \$16612 VSS AND201
* cell instance $38713 m0 *1 2353.66,5745.5
X$38713 \$18 \$18104 \$18310 VSS INVR02
* cell instance $38717 m0 *1 2384.14,5745.5
X$38717 \$18 \$17364 \$18435 VSS INVR06
* cell instance $38718 m0 *1 2413.54,5745.5
X$38718 \$18 \$18310 \$17621 VSS INVR02
* cell instance $38720 m0 *1 2433.24,5745.5
X$38720 \$15104 \$18206 \$18 \$18109 VSS OR2101
* cell instance $38734 m0 *1 2549.4,5745.5
X$38734 \$18207 \$18 \$18438 VSS INVR01
* cell instance $38741 r180 *1 2624.8,5745.5
X$38741 \$18441 \$18116 \$18 \$13378 VSS OR2101
* cell instance $38746 r180 *1 2672.02,5745.5
X$38746 \$17357 \$18442 \$18443 \$18 \$18118 VSS OR3101
* cell instance $38749 r180 *1 2705.09,5745.5
X$38749 \$18443 \$18119 \$18445 \$18 VSS NND201
* cell instance $38752 r180 *1 2731.9,5745.5
X$38752 \$18 \$17754 \$18441 VSS INVR02
* cell instance $38753 r180 *1 2752.9,5745.5
X$38753 \$14990 \$17541 \$18 \$18128 VSS OR2101
* cell instance $38758 r180 *1 2801.35,5745.5
X$38758 \$18 \$14990 \$18447 VSS INVR04
* cell instance $38767 m0 *1 2854.22,5745.5
X$38767 \$18319 \$18445 \$18128 \$18 \$10061 VSS OR3101
* cell instance $38775 r180 *1 2954.1,5745.5
X$38775 \$18 \$18450 \$18319 VSS INVR02
* cell instance $38779 m0 *1 2965.27,5745.5
X$38779 \$16325 \$18451 \$18132 \$18 VSS NND201
* cell instance $38783 m0 *1 2994.13,5745.5
X$38783 \$18 \$16196 \$18450 VSS INVR06
* cell instance $38786 m0 *1 3033.76,5745.5
X$38786 \$18 \$14512 \$18438 VSS INVR02
* cell instance $38788 r180 *1 3071.78,5745.5
X$38788 \$18136 \$18 \$18137 VSS INVR01
* cell instance $38792 m0 *1 3086.12,5745.5
X$38792 \$18 \$16644 \$18457 VSS INVR02
* cell instance $38795 r180 *1 3135.75,5745.5
X$38795 \$18140 \$13378 \$11228 \$18 VSS NND201
* cell instance $38798 m0 *1 3148.38,5745.5
X$38798 \$11228 \$18143 \$18 \$13378 VSS OR2101
* cell instance $39515 m0 *1 52.75,5568.1
X$39515 \$18 \$16509 \$17382 VSS INVR03
* cell instance $39519 m0 *1 94.2,5568.1
X$39519 \$18 \$17599 \$17254 VSS INVR02
* cell instance $39526 m0 *1 154.21,5568.1
X$39526 \$18 \$17668 \$17254 VSS INVR03
* cell instance $39530 r180 *1 220.18,5568.1
X$39530 \$17601 \$17670 \$17669 \$18 VSS XNR201
* cell instance $39534 r180 *1 243.8,5568.1
X$39534 \$18 \$17785 \$17512 VSS INVR02
* cell instance $39535 r180 *1 260.6,5568.1
X$39535 \$18 \$17674 \$17601 VSS INVR02
* cell instance $39538 m0 *1 273.47,5568.1
X$39538 \$18 \$16987 \$17788 VSS INVR02
* cell instance $39540 m0 *1 292.37,5568.1
X$39540 \$18 \$17387 \$17670 VSS INVR02
* cell instance $39543 m0 *1 320.6,5568.1
X$39543 \$18 \$17785 \$17674 \$17386 VSS AND201
* cell instance $39545 m0 *1 347.71,5568.1
X$39545 \$17299 \$17788 \$17386 \$17675 \$17792 \$18 VSS NND401
* cell instance $39549 m0 *1 405.9,5568.1
X$39549 \$17675 \$17608 \$18 \$17795 VSS OR2101
* cell instance $39551 r180 *1 443.71,5568.1
X$39551 \$17119 \$16520 \$16523 \$18 VSS NND201
* cell instance $39554 m0 *1 451.49,5568.1
X$39554 \$17678 \$18 \$17677 VSS INVR01
* cell instance $39557 m0 *1 472.42,5568.1
X$39557 \$16995 \$17608 \$17643 \$18 VSS XNR201
* cell instance $39559 r180 *1 544.66,5568.1
X$39559 \$18 \$16085 \$17643 \$16407 VSS AND201
* cell instance $39575 m0 *1 647.87,5568.1
X$39575 \$18 \$17215 \$17797 VSS INVR03
* cell instance $39581 r180 *1 714.84,5568.1
X$39581 \$18 \$17397 \$17798 VSS INVR03
* cell instance $39585 m0 *1 725.5,5568.1
X$39585 \$18 \$17304 \$17647 VSS INVR02
* cell instance $39586 m0 *1 742.3,5568.1
X$39586 \$17401 \$17306 \$17124 \$18 VSS NND201
* cell instance $39589 m0 *1 772.19,5568.1
X$39589 \$16549 \$18 \$15633 \$17219 \$16094 VSS AND301
* cell instance $39591 m0 *1 805.79,5568.1
X$39591 \$18 \$17647 \$17124 VSS INVR02
* cell instance $39594 r180 *1 859.36,5568.1
X$39594 \$18 \$17959 \$17122 VSS INVR06
* cell instance $39596 m0 *1 859.96,5568.1
X$39596 \$16554 \$17306 \$17804 \$18 VSS NND201
* cell instance $39597 r180 *1 901.96,5568.1
X$39597 \$17803 \$18 \$17004 VSS INVR05
* cell instance $39600 m0 *1 915.16,5568.1
X$39600 \$17613 \$16547 \$17804 \$18 VSS NND201
* cell instance $39602 m0 *1 932.57,5568.1
X$39602 \$18 \$3880 \$17805 VSS INVR06
* cell instance $39603 r180 *1 979.95,5568.1
X$39603 \$17689 \$17410 \$17413 \$18 VSS NND201
* cell instance $39607 r180 *1 1009.95,5568.1
X$39607 \$18 \$17662 \$17403 VSS INVR02
* cell instance $39611 m0 *1 1017.56,5568.1
X$39611 \$17406 \$17410 \$17412 \$18 VSS NND201
* cell instance $39615 m0 *1 1044.37,5568.1
X$39615 \$18 \$17693 \$17904 VSS INVR02
* cell instance $39616 m0 *1 1061.17,5568.1
X$39616 \$18 \$17904 \$17309 VSS INVR02
* cell instance $39617 m0 *1 1079.9,5568.1
X$39617 \$17662 \$17411 \$17419 \$18 VSS NND201
* cell instance $39625 r180 *1 1253.42,5568.1
X$39625 \$17699 \$17701 \$17663 \$18 VSS NND201
* cell instance $39626 m0 *1 1253.42,5568.1
X$39626 \$18 \$17700 \$17425 VSS INVR02
* cell instance $39630 r180 *1 1301.28,5568.1
X$39630 \$17701 \$17813 \$17323 \$18 VSS NND201
* cell instance $39631 r180 *1 1322.28,5568.1
X$39631 \$17323 \$17663 \$18 \$17417 VSS OR2101
* cell instance $39635 m0 *1 1342.58,5568.1
X$39635 \$18 \$17661 \$17529 VSS INVR03
* cell instance $39637 m0 *1 1364.82,5568.1
X$39637 \$18 \$17705 \$17661 VSS INVR02
* cell instance $39640 m0 *1 1484.2,5568.1
X$39640 \$18 \$17430 \$17709 VSS INVR03
* cell instance $39644 r180 *1 1540.26,5568.1
X$39644 \$17825 \$17821 \$18 \$17824 VSS OR2101
* cell instance $39646 m0 *1 1549.32,5568.1
X$39646 \$18 \$17616 \$17709 \$17708 VSS AND201
* cell instance $39650 m0 *1 1585.51,5568.1
X$39650 \$17433 \$17710 \$18 \$17616 VSS OR2101
* cell instance $39651 r180 *1 1635.91,5568.1
X$39651 \$18 \$17708 \$17334 VSS INVR06
* cell instance $39652 m0 *1 1635.91,5568.1
X$39652 \$18 \$17713 \$17225 VSS INVR03
* cell instance $39657 m0 *1 1685.44,5568.1
X$39657 \$18 \$17659 \$17031 VSS INVR03
* cell instance $39660 m0 *1 1709.35,5568.1
X$39660 \$17434 \$17828 \$17030 \$17717 \$17659 \$18 VSS AND401
* cell instance $39664 r180 *1 1777.16,5568.1
X$39664 \$18 \$17720 \$17719 VSS INVR02
* cell instance $39692 r180 *1 2094.43,5568.1
X$39692 \$17619 \$18 \$17587 VSS INVR01
* cell instance $39694 r180 *1 2111.23,5568.1
X$39694 \$18 \$17591 \$17655 VSS INVR02
* cell instance $39696 r180 *1 2131.44,5568.1
X$39696 \$18 \$17655 \$17346 VSS INVR03
* cell instance $39699 r180 *1 2191.63,5568.1
X$39699 \$17441 \$17619 \$16735 \$17727 \$17621 \$16736 \$18 VSS NND501
* cell instance $39703 r180 *1 2229,5568.1
X$39703 \$15097 \$18 \$17838 VSS INVR05
* cell instance $39704 r180 *1 2250.01,5568.1
X$39704 \$16741 \$17591 \$18 \$17746 VSS OR2101
* cell instance $39708 m0 *1 2304.65,5568.1
X$39708 \$15104 \$17735 \$18 \$16741 VSS OR2101
* cell instance $39709 r180 *1 2342.45,5568.1
X$39709 \$18 \$17622 \$17587 VSS INVR02
* cell instance $39711 m0 *1 2345.25,5568.1
X$39711 \$18 \$17037 \$17350 VSS INVR03
* cell instance $39718 r180 *1 2432.01,5568.1
X$39718 \$18 \$17622 \$17445 \$17740 VSS AND201
* cell instance $39727 r180 *1 2530.26,5568.1
X$39727 \$17541 \$17744 \$17645 \$17742 \$17741 \$18 VSS AND401
* cell instance $39728 m0 *1 2530.26,5568.1
X$39728 \$18 \$17746 \$17762 VSS INVR06
* cell instance $39730 m0 *1 2562.24,5568.1
X$39730 \$17449 \$17645 \$18 \$15259 VSS OR2101
* cell instance $39731 r180 *1 2595.84,5568.1
X$39731 \$17748 \$18 \$17850 VSS INVR01
* cell instance $39732 r180 *1 2616.84,5568.1
X$39732 \$17233 \$17740 \$18 \$13378 VSS OR2101
* cell instance $39733 m0 *1 2616.84,5568.1
X$39733 \$18 \$15259 \$17850 VSS INVR03
* cell instance $39736 m0 *1 2646.24,5568.1
X$39736 \$14343 \$13378 \$17359 \$18 VSS PDDR04
* cell instance $39737 r180 *1 2763.84,5568.1
X$39737 \$17230 \$17232 \$17735 \$17752 \$17445 \$17353 \$18 VSS NND501
* cell instance $39738 m0 *1 2763.84,5568.1
X$39738 \$17754 \$18 \$10630 VSS INVR05
* cell instance $39740 m0 *1 2793.25,5568.1
X$39740 \$18 \$14936 \$17858 VSS INVR06
* cell instance $39746 m0 *1 2860.1,5568.1
X$39746 \$18 \$17360 \$17066 \$14936 VSS AND201
* cell instance $39749 r180 *1 2906.9,5568.1
X$39749 \$18 \$17461 \$17447 VSS INVR02
* cell instance $39751 r180 *1 2942.36,5568.1
X$39751 \$18 \$16302 \$17923 VSS INVR06
* cell instance $39755 r180 *1 2965.55,5568.1
X$39755 \$18 \$17633 \$17923 VSS INVR03
* cell instance $39758 m0 *1 2977.93,5568.1
X$39758 \$18 \$10069 \$17077 VSS INVR03
* cell instance $39759 m0 *1 2994.73,5568.1
X$39759 \$18 \$10069 \$17916 VSS INVR03
* cell instance $39761 m0 *1 3013.63,5568.1
X$39761 \$18 \$17762 \$17916 VSS INVR06
* cell instance $39763 r180 *1 3066.14,5568.1
X$39763 \$17078 \$17633 \$18 \$16196 VSS OR2101
* cell instance $39765 r180 *1 3090.06,5568.1
X$39765 \$17468 \$17369 \$18 \$16194 VSS OR2101
* cell instance $39768 r180 *1 3113.74,5568.1
X$39768 \$18 \$17765 \$17867 VSS INVR03
* cell instance $39772 m0 *1 3131.49,5568.1
X$39772 \$17463 \$18 \$15268 \$17464 VSS NOR201
* cell instance $39774 r180 *1 3204.02,5568.1
X$39774 \$17470 \$18 \$17074 \$17078 VSS NOR201
* cell instance $39776 m0 *1 3204.02,5568.1
X$39776 \$14657 \$18 \$17765 VSS INVR05
* cell instance $39790 m0 *1 3329.5,5568.1
X$39790 \$18 \$17770 \$17078 \$17077 VSS AND201
* cell instance $39793 m0 *1 3371.57,5568.1
X$39793 \$17770 \$17771 \$18 \$11228 VSS OR2101
* cell instance $39798 m0 *1 3414.98,5568.1
X$39798 \$18 \$17771 \$17473 VSS INVR02
* cell instance $40209 m0 *1 6706.59,5568.1
X$40209 \$17773 \$18 \$17477 VSS INVR05
* cell instance $40486 r180 *1 1096.69,6455.1
X$40486 \$19453 \$19813 \$18 \$19814 VSS OR2101
* cell instance $40500 r180 *1 1212.79,6455.1
X$40500 \$18 \$19816 \$19821 VSS INVR03
* cell instance $40509 r180 *1 1276.7,6455.1
X$40509 \$18 \$19854 \$19816 VSS INVR03
* cell instance $40538 m0 *1 1489.51,6455.1
X$40538 \$18 \$19825 \$19854 VSS INVR02
* cell instance $40960 m0 *1 4874.64,6455.1
X$40960 \$18 \$14672 \$19861 VSS INVR03
* cell instance $40983 m0 *1 5057.34,6455.1
X$40983 \$18 \$19862 \$17475 VSS INVR06
* cell instance $41459 m0 *1 179.78,6277.7
X$41459 \$19364 \$19366 \$19426 \$18 VSS NND201
* cell instance $41463 m0 *1 214.21,6277.7
X$41463 \$18 \$13379 \$19737 VSS INVR06
* cell instance $41465 m0 *1 252.66,6277.7
X$41465 \$19058 \$19366 \$19615 \$18 VSS NND201
* cell instance $41467 r180 *1 286.26,6277.7
X$41467 \$18 \$19560 \$19426 VSS INVR02
* cell instance $41473 m0 *1 320.99,6277.7
X$41473 \$18673 \$19615 \$19617 \$18 VSS NND201
* cell instance $41475 m0 *1 346.26,6277.7
X$41475 \$18 \$19616 \$18673 VSS INVR02
* cell instance $41484 r180 *1 457.01,6277.7
X$41484 \$19743 \$18 \$19619 \$19618 VSS NOR201
* cell instance $41485 m0 *1 457.62,6277.7
X$41485 \$18 \$19743 \$19744 VSS INVR03
* cell instance $41490 m0 *1 503.82,6277.7
X$41490 \$18 \$19373 \$19619 VSS INVR02
* cell instance $41494 m0 *1 531.34,6277.7
X$41494 \$18 \$18581 \$19618 VSS INVR03
* cell instance $41505 r180 *1 640.14,6277.7
X$41505 \$18 \$19686 \$19570 VSS INVR03
* cell instance $41509 m0 *1 650.57,6277.7
X$41509 \$18 \$19571 \$19745 VSS INVR02
* cell instance $41512 m0 *1 680.52,6277.7
X$41512 \$18 \$19745 \$19625 VSS INVR02
* cell instance $41522 r180 *1 779.11,6277.7
X$41522 \$18 \$19747 \$19686 VSS INVR02
* cell instance $41523 m0 *1 780.22,6277.7
X$41523 \$18 \$19629 \$19747 VSS INVR02
* cell instance $41525 r180 *1 818.02,6277.7
X$41525 \$19749 \$19632 \$18 \$19586 VSS OR2101
* cell instance $41526 m0 *1 818.02,6277.7
X$41526 \$18669 \$18 \$19750 VSS INVR05
* cell instance $41529 r180 *1 862.68,6277.7
X$41529 \$19749 \$18 \$17803 VSS INVR01
* cell instance $41541 r180 *1 957.71,6277.7
X$41541 \$18 \$19174 \$19634 VSS INVR02
* cell instance $41546 m0 *1 1084.72,6277.7
X$41546 \$18 \$19592 \$19707 VSS INVR03
* cell instance $41548 m0 *1 1110.06,6277.7
X$41548 \$19453 \$19339 \$18 \$19756 VSS OR2101
* cell instance $41550 r180 *1 1146.37,6277.7
X$41550 \$19756 \$18 \$19757 VSS INVR01
* cell instance $41551 m0 *1 1146.37,6277.7
X$41551 \$18 \$19450 \$19591 VSS INVR03
* cell instance $41556 m0 *1 1263.92,6277.7
X$41556 \$18 \$7705 \$19760 VSS INVR02
* cell instance $41557 m0 *1 1280.72,6277.7
X$41557 \$18 \$19761 \$18941 VSS INVR03
* cell instance $41566 r180 *1 1379.42,6277.7
X$41566 \$18 \$19193 \$19787 VSS INVR02
* cell instance $41578 m0 *1 1594.83,6277.7
X$41578 \$18 \$19765 \$19195 VSS INVR02
* cell instance $41587 m0 *1 1670.94,6277.7
X$41587 \$18 \$19770 \$19724 VSS INVR02
* cell instance $41589 r180 *1 1704.54,6277.7
X$41589 \$18 \$19771 \$19770 VSS INVR02
* cell instance $41593 r180 *1 1736.54,6277.7
X$41593 \$18 \$18849 \$19771 VSS INVR03
* cell instance $41596 m0 *1 1746.2,6277.7
X$41596 \$18 \$19771 \$19650 VSS INVR02
* cell instance $41604 m0 *1 1801.48,6277.7
X$41604 \$18 \$19651 \$19194 VSS INVR03
* cell instance $41887 r180 *1 4183.48,6277.7
X$41887 \$18 \$19605 \$19604 VSS INVR03
* cell instance $41979 m0 *1 4904.13,6277.7
X$41979 \$18 \$19775 \$15150 VSS INVR06
* cell instance $42475 m0 *1 1476.11,7342.1
X$42475 \$19466 \$18 \$19937 VSS INVR05
* cell instance $42785 m0 *1 3957.03,7342.1
X$42785 \$18 \$19928 \$19216 VSS INVR06
* cell instance $42835 r180 *1 4402.37,7342.1
X$42835 \$18 \$19929 \$19218 VSS INVR06
* cell instance $43397 m0 *1 3900.65,7519.5
X$43397 \$18 \$19949 \$19948 VSS INVR06
* cell instance $43398 m0 *1 3930.05,7519.5
X$43398 \$18 \$19948 \$19962 VSS INVR06
* cell instance $43487 m0 *1 4657.71,7519.5
X$43487 \$18 \$19876 \$19951 VSS INVR06
* cell instance $43505 r180 *1 4919.75,7519.5
X$43505 \$8743 \$19876 \$19969 \$I331398 \$19954 \$18 VSS DFCL11
* cell instance $43511 m0 *1 4939.2,7519.5
X$43511 \$18 \$19956 \$19955 VSS INVR06
* cell instance $43544 m0 *1 5208.61,7519.5
X$43544 \$18 \$13915 \$19943 VSS INVR06
* cell instance $44607 m0 *1 4851,7874.3
X$44607 \$18 \$19977 \$19977 VSS INVR02
* cell instance $44631 r180 *1 5076.98,7874.3
X$44631 \$19988 \$18 \$19990 \$19989 VSS NOR201
* cell instance $44638 r180 *1 5132.19,7874.3
X$44638 \$18 \$19990 \$19992 \$20008 VSS AND201
* cell instance $44641 m0 *1 5145,7874.3
X$44641 \$18 \$19992 \$19993 VSS INVR02
* cell instance $44643 m0 *1 5169.83,7874.3
X$44643 \$19995 \$18 \$19981 VSS INVR05
* cell instance $44657 r180 *1 5316.99,7874.3
X$44657 \$18 \$19982 \$19980 VSS INVR03
* cell instance $45106 m0 *1 4774.2,8051.7
X$45106 \$18 \$20038 \$20039 VSS INVR02
* cell instance $45116 m0 *1 4860.2,8051.7
X$45116 \$18 \$19979 \$20041 VSS INVR03
* cell instance $45126 m0 *1 4931.6,8051.7
X$45126 \$18 \$19978 \$19979 VSS INVR03
* cell instance $45131 m0 *1 4971.75,8051.7
X$45131 \$18 \$19979 \$20005 VSS INVR02
* cell instance $45133 m0 *1 4988.55,8051.7
X$45133 \$20046 \$18 \$19979 VSS INVR01
* cell instance $45144 m0 *1 5082.25,8051.7
X$45144 \$20012 \$20007 \$18 \$20046 VSS OR2101
* cell instance $45151 m0 *1 5137.9,8051.7
X$45151 \$18 \$19993 \$20051 VSS INVR03
* cell instance $45152 m0 *1 5154.7,8051.7
X$45152 \$18 \$20010 \$20052 VSS INVR02
* cell instance $45156 m0 *1 5186.98,8051.7
X$45156 \$18 \$20052 \$20054 VSS INVR02
* cell instance $45620 m0 *1 4874.64,6809.9
X$45620 \$18 \$19861 \$19907 VSS INVR03
* cell instance $45654 m0 *1 5142.78,6809.9
X$45654 \$18 \$19893 \$19907 VSS INVR06
* cell instance $46121 m0 *1 4019.4,6987.3
X$46121 \$18 \$19904 \$19903 VSS INVR06
* cell instance $46133 m0 *1 4124.4,6987.3
X$46133 \$18 \$19906 \$19654 VSS INVR06
* cell instance $46727 m0 *1 4382.99,6632.5
X$46727 \$19872 \$18 \$19885 VSS INVR05
* cell instance $46728 m0 *1 4408.19,6632.5
X$46728 \$18 \$19886 \$19885 VSS INVR03
* cell instance $46745 m0 *1 4546.55,6632.5
X$46745 \$18 \$19889 \$19866 VSS INVR06
* cell instance $46800 m0 *1 5004.28,6632.5
X$46800 \$18 \$13913 \$19890 VSS INVR06
* cell instance $46801 m0 *1 5033.68,6632.5
X$46801 \$18 \$19874 \$19890 VSS INVR03
* cell instance $46803 m0 *1 5058.91,6632.5
X$46803 \$8743 \$19876 \$19872 \$I331440 \$19877 \$18 VSS DFCL11
* cell instance $46804 m0 *1 5159.71,6632.5
X$46804 \$18 \$19877 \$19894 VSS INVR03
* cell instance $46806 m0 *1 5178.6,6632.5
X$46806 \$18 \$19866 \$19894 VSS INVR06
* cell instance $47272 m0 *1 4017.34,1133.1
X$47272 \$18 \$1274 \$1220 VSS INVR02
* cell instance $47279 m0 *1 4082.45,1133.1
X$47279 \$18 \$1275 \$1190 VSS INVR02
* cell instance $47280 m0 *1 4200.05,1133.1
X$47280 \$18 \$1278 \$1279 VSS INVR03
* cell instance $47282 m0 *1 4218.94,1133.1
X$47282 \$18 \$1281 \$1280 VSS INVR06
* cell instance $47283 m0 *1 4248.35,1133.1
X$47283 \$18 \$1280 \$1279 VSS INVR04
* cell instance $47286 m0 *1 4280.87,1133.1
X$47286 \$18 \$1284 \$1336 VSS INVR02
* cell instance $47288 m0 *1 4297.67,1133.1
X$47288 \$18 \$1285 \$1221 VSS INVR02
* cell instance $47290 r180 *1 4356.7,1133.1
X$47290 \$1285 \$18 \$1141 \$1286 VSS NOR201
* cell instance $47293 m0 *1 4368.15,1133.1
X$47293 \$18 \$1221 \$1338 VSS INVR02
* cell instance $47298 m0 *1 4493.57,1133.1
X$47298 \$1292 \$1190 \$1293 \$1340 \$1238 \$1291 \$18 VSS NND501
* cell instance $47299 m0 *1 4543.98,1133.1
X$47299 \$1293 \$18 \$1294 VSS INVR01
* cell instance $47300 r180 *1 4594.38,1133.1
X$47300 \$1241 \$1297 \$1296 \$18 VSS XNR201
* cell instance $47301 m0 *1 4594.38,1133.1
X$47301 \$18 \$1297 \$1298 VSS INVR06
* cell instance $47304 m0 *1 4635.55,1133.1
X$47304 \$18 \$1113 \$1243 VSS INVR02
* cell instance $47309 m0 *1 4674.12,1133.1
X$47309 \$18 \$1243 \$1300 VSS INVR03
* cell instance $47330 m0 *1 4838.63,1133.1
X$47330 \$18 \$1301 \$1302 VSS INVR02
* cell instance $47333 r180 *1 4881.53,1133.1
X$47333 \$18 \$987 \$1301 VSS INVR02
* cell instance $47338 m0 *1 4900.65,1133.1
X$47338 \$18 \$1305 \$1304 \$1155 VSS AND201
* cell instance $47341 m0 *1 4929.6,1133.1
X$47341 \$18 \$1158 \$1307 VSS INVR03
* cell instance $47343 m0 *1 4946.4,1133.1
X$47343 \$18 \$1308 \$1137 VSS INVR06
* cell instance $47347 m0 *1 4990.23,1133.1
X$47347 \$1155 \$1061 \$1309 \$18 VSS XNR201
* cell instance $47352 m0 *1 5060.22,1133.1
X$47352 \$18 \$1169 \$1305 \$1310 VSS AND201
* cell instance $47354 m0 *1 5094.78,1133.1
X$47354 \$18 \$1314 \$1310 \$1309 VSS AND201
* cell instance $47356 m0 *1 5119.98,1133.1
X$47356 \$18 \$1249 \$1250 VSS INVR02
* cell instance $47358 m0 *1 5145.02,1133.1
X$47358 \$18 \$1327 \$1061 \$1315 VSS AND201
* cell instance $47361 m0 *1 5175.57,1133.1
X$47361 \$1252 \$18 \$1327 \$1314 VSS NOR201
* cell instance $47362 m0 *1 5209.18,1133.1
X$47362 \$18 \$1250 \$1063 VSS INVR02
* cell instance $47367 m0 *1 5252.96,1133.1
X$47367 \$18 \$1252 \$1347 VSS INVR03
* cell instance $47368 m0 *1 5370.57,1133.1
X$47368 \$18 \$1318 \$1256 VSS INVR02
* cell instance $47386 m0 *1 5514.6,1133.1
X$47386 \$18 \$1259 \$1319 VSS INVR02
* cell instance $47388 m0 *1 5531.41,1133.1
X$47388 \$18 \$1061 \$1123 VSS INVR06
* cell instance $47389 m0 *1 5561.41,1133.1
X$47389 \$18 \$1061 \$1259 VSS INVR02
* cell instance $47804 m0 *1 3981.6,1842.7
X$47804 \$18 \$2130 \$2123 VSS INVR06
* cell instance $47805 m0 *1 4113.91,1842.7
X$47805 \$18 \$2130 \$1275 VSS INVR03
* cell instance $47809 m0 *1 4147.33,1842.7
X$47809 \$18 \$2406 \$2405 VSS INVR03
* cell instance $47810 m0 *1 4164.13,1842.7
X$47810 \$18 \$2261 \$2406 VSS INVR02
* cell instance $47813 m0 *1 4193.6,1842.7
X$47813 \$18 \$2272 \$2135 VSS INVR03
* cell instance $47817 m0 *1 4326.16,1842.7
X$47817 \$18 \$2135 \$2413 VSS INVR02
* cell instance $47818 m0 *1 4342.96,1842.7
X$47818 \$18 \$2413 \$2414 VSS INVR02
* cell instance $47821 m0 *1 4366.05,1842.7
X$47821 \$18 \$2413 \$2449 VSS INVR02
* cell instance $47822 m0 *1 4382.85,1842.7
X$47822 \$18 \$2449 \$1294 VSS INVR03
* cell instance $47824 m0 *1 4405.8,1842.7
X$47824 \$18 \$2415 \$2363 VSS INVR03
* cell instance $47826 m0 *1 4422.6,1842.7
X$47826 \$18 \$2418 \$2417 VSS INVR06
* cell instance $47828 m0 *1 4457.73,1842.7
X$47828 \$18 \$2180 \$2125 VSS INVR03
* cell instance $47830 m0 *1 4474.94,1842.7
X$47830 \$18 \$2077 \$1611 VSS INVR03
* cell instance $47831 m0 *1 4491.74,1842.7
X$47831 \$18 \$2420 \$2417 VSS INVR03
* cell instance $47832 m0 *1 4508.54,1842.7
X$47832 \$18 \$2141 \$2420 VSS INVR02
* cell instance $47834 r180 *1 4544.8,1842.7
X$47834 \$18 \$1446 \$2323 VSS INVR02
* cell instance $47835 r180 *1 4582.6,1842.7
X$47835 \$2364 \$2363 \$2364 \$18 VSS XNR201
* cell instance $47836 m0 *1 4582.6,1842.7
X$47836 \$2232 \$18 \$2424 VSS INVR01
* cell instance $47837 m0 *1 4595.2,1842.7
X$47837 \$18 \$2277 \$2425 VSS INVR03
* cell instance $47838 m0 *1 4612.31,1842.7
X$47838 \$18 \$2425 \$1999 VSS INVR03
* cell instance $47843 r180 *1 4725.03,1842.7
X$47843 \$18 \$2432 \$2431 VSS INVR02
* cell instance $47849 r180 *1 4888.3,1842.7
X$47849 \$2242 \$2309 \$18 \$2370 \$2326 VSS NOR301
* cell instance $47852 m0 *1 4933.42,1842.7
X$47852 \$2331 \$2441 \$2437 \$18 VSS XNR201
* cell instance $47853 r180 *1 4984.34,1842.7
X$47853 \$2370 \$18 \$1963 VSS INVR01
* cell instance $47854 m0 *1 4984.94,1842.7
X$47854 \$18 \$2246 \$2436 VSS INVR02
* cell instance $47855 r180 *1 5031.14,1842.7
X$47855 \$18 \$2441 \$2442 VSS INVR06
* cell instance $47859 m0 *1 5044.94,1842.7
X$47859 \$18 \$2443 \$2444 VSS INVR02
* cell instance $47862 m0 *1 5074.26,1842.7
X$47862 \$18 \$1236 \$2374 VSS INVR03
* cell instance $47863 m0 *1 5091.06,1842.7
X$47863 \$18 \$1281 \$2447 VSS INVR02
* cell instance $47864 m0 *1 5107.86,1842.7
X$47864 \$18 \$2447 \$2442 VSS INVR03
* cell instance $47865 m0 *1 5124.66,1842.7
X$47865 \$18 \$2446 \$2331 VSS INVR02
* cell instance $48338 m0 *1 596.03,2197.5
X$48338 \$18 \$2924 \$2971 VSS INVR03
* cell instance $48343 m0 *1 632.97,2197.5
X$48343 \$18 \$2972 \$2971 VSS INVR04
* cell instance $48363 m0 *1 803.61,2197.5
X$48363 \$2975 \$18 \$2972 VSS INVR05
* cell instance $48422 m0 *1 1279.42,2197.5
X$48422 \$18 \$2977 \$2976 VSS INVR06
* cell instance $48444 m0 *1 1472.02,2197.5
X$48444 \$18 \$2925 \$2768 VSS INVR02
* cell instance $48456 m0 *1 1558.63,2197.5
X$48456 \$18 \$2978 \$2926 VSS INVR02
* cell instance $48477 m0 *1 1731.03,2197.5
X$48477 \$18 \$2979 \$2980 VSS INVR03
* cell instance $48482 r180 *1 1804.11,2197.5
X$48482 \$2927 \$2981 \$2834 \$18 VSS XNR201
* cell instance $48483 m0 *1 1804.66,2197.5
X$48483 \$18 \$2983 \$2835 \$2982 VSS AND201
* cell instance $48485 m0 *1 1839.51,2197.5
X$48485 \$18 \$2983 \$2979 VSS INVR02
* cell instance $48497 m0 *1 1937.32,2197.5
X$48497 \$18 \$3152 \$2928 VSS INVR02
* cell instance $48501 m0 *1 1971.9,2197.5
X$48501 \$18 \$2894 \$2895 VSS INVR06
* cell instance $48515 r180 *1 2119.42,2197.5
X$48515 \$18 \$2988 \$2987 VSS INVR02
* cell instance $48544 m0 *1 2325.82,2197.5
X$48544 \$18 \$2989 \$2990 VSS INVR02
* cell instance $48545 m0 *1 2343.6,2197.5
X$48545 \$18 \$2991 \$2992 VSS INVR03
* cell instance $48550 m0 *1 2383.96,2197.5
X$48550 \$18 \$2993 \$2989 VSS INVR02
* cell instance $48620 m0 *1 2945.25,2197.5
X$48620 \$18 \$2895 \$2897 VSS INVR06
* cell instance $48735 r180 *1 3897.6,2197.5
X$48735 \$18 \$2930 \$2996 VSS INVR03
* cell instance $48736 m0 *1 3897.6,2197.5
X$48736 \$18 \$2996 \$3115 VSS INVR03
* cell instance $48738 m0 *1 3916.5,2197.5
X$48738 \$18 \$2897 \$3115 VSS INVR06
* cell instance $48743 r180 *1 3990.99,2197.5
X$48743 \$18 \$2845 \$2779 VSS INVR03
* cell instance $48744 m0 *1 3992.27,2197.5
X$48744 \$18 \$2842 \$2998 VSS INVR03
* cell instance $48747 m0 *1 4011.01,2197.5
X$48747 \$18 \$3079 \$2515 VSS INVR06
* cell instance $48748 m0 *1 4040.41,2197.5
X$48748 \$3000 \$18 \$2998 VSS INVR05
* cell instance $48749 m0 *1 4065.61,2197.5
X$48749 \$18 \$3002 \$1560 \$2843 VSS AND201
* cell instance $48750 r180 *1 4107.61,2197.5
X$48750 \$18 \$2781 \$2784 VSS INVR03
* cell instance $48755 r180 *1 4171.86,2197.5
X$48755 \$2846 \$18 \$2765 \$2788 \$2134 VSS NND301
* cell instance $48756 m0 *1 4171.86,2197.5
X$48756 \$18 \$3005 \$3004 \$2843 VSS AND201
* cell instance $48758 m0 *1 4200.32,2197.5
X$48758 \$18 \$2851 \$2850 VSS INVR02
* cell instance $48763 m0 *1 4239.12,2197.5
X$48763 \$3006 \$18 \$1828 VSS INVR01
* cell instance $48765 m0 *1 4251.72,2197.5
X$48765 \$3008 \$18 \$2765 \$3007 VSS NOR201
* cell instance $48767 m0 *1 4287.39,2197.5
X$48767 \$18 \$2790 \$2852 VSS INVR02
* cell instance $48768 m0 *1 4304.19,2197.5
X$48768 \$3010 \$18 \$3008 \$2851 VSS NOR201
* cell instance $48769 m0 *1 4337.79,2197.5
X$48769 \$3012 \$18 \$3011 VSS INVR05
* cell instance $48774 m0 *1 4386.55,2197.5
X$48774 \$3013 \$3015 \$18 \$3010 VSS OR2101
* cell instance $48776 r180 *1 4454.27,2197.5
X$48776 \$2942 \$2524 \$3084 \$3015 \$3016 \$18 VSS AOI401
* cell instance $48777 m0 *1 4454.27,2197.5
X$48777 \$3016 \$18 \$2650 VSS INVR05
* cell instance $48780 m0 *1 4485.91,2197.5
X$48780 \$3016 \$2943 \$18 \$2856 VSS OR2101
* cell instance $48783 r180 *1 4529.77,2197.5
X$48783 \$18 \$3176 \$2275 VSS INVR02
* cell instance $48785 r180 *1 4567.92,2197.5
X$48785 \$3013 \$18 \$2943 \$2857 VSS NOR201
* cell instance $48788 r180 *1 4609.09,2197.5
X$48788 \$2858 \$18 \$2656 \$3021 VSS NOR201
* cell instance $48790 m0 *1 4609.1,2197.5
X$48790 \$18 \$2619 \$2701 VSS INVR03
* cell instance $48791 r180 *1 4642.7,2197.5
X$48791 \$18 \$3024 \$3021 VSS INVR02
* cell instance $48794 m0 *1 4655.88,2197.5
X$48794 \$18 \$3025 \$2860 VSS INVR02
* cell instance $48796 r180 *1 4748.3,2197.5
X$48796 \$2432 \$3027 \$2661 \$2496 \$2598 \$2558 \$2524 \$2701 \$3025 \$18 VSS
+ AND801
* cell instance $48797 m0 *1 4748.3,2197.5
X$48797 \$18 \$3027 \$3187 \$2905 VSS AND201
* cell instance $48800 r180 *1 4826.25,2197.5
X$48800 \$2559 \$2529 \$2808 \$2563 \$2441 \$18 VSS NND401
* cell instance $48801 m0 *1 4826.25,2197.5
X$48801 \$18 \$2559 \$2707 VSS INVR02
* cell instance $48802 m0 *1 4843.05,2197.5
X$48802 \$18 \$2865 \$3031 VSS INVR02
* cell instance $48803 m0 *1 4859.85,2197.5
X$48803 \$2183 \$18 \$3032 VSS INVR05
* cell instance $48804 r180 *1 4914.45,2197.5
X$48804 \$18 \$2496 \$2140 VSS INVR06
* cell instance $48807 m0 *1 4930.81,2197.5
X$48807 \$2598 \$18 \$2955 VSS INVR05
* cell instance $48810 m0 *1 4973.59,2197.5
X$48810 \$2820 \$2868 \$3036 \$18 VSS XNR201
* cell instance $48812 m0 *1 5011.4,2197.5
X$48812 \$18 \$2711 \$2821 VSS INVR06
* cell instance $48815 m0 *1 5051.17,2197.5
X$48815 \$18 \$3036 \$3038 VSS INVR02
* cell instance $48817 m0 *1 5069.41,2197.5
X$48817 \$18 \$3039 \$3038 VSS INVR06
* cell instance $48818 m0 *1 5098.81,2197.5
X$48818 \$18 \$3041 \$3040 VSS INVR06
* cell instance $48819 m0 *1 5128.21,2197.5
X$48819 \$18 \$3040 \$2599 VSS INVR02
* cell instance $48820 m0 *1 5145.01,2197.5
X$48820 \$18 \$2502 \$3040 VSS INVR03
* cell instance $48821 r180 *1 5178.61,2197.5
X$48821 \$18 \$3045 \$2955 VSS INVR03
* cell instance $48823 m0 *1 5186.67,2197.5
X$48823 \$18 \$2823 \$2868 VSS INVR03
* cell instance $49519 m0 *1 1881,2020.1
X$49519 \$18 \$2685 \$2634 VSS INVR02
* cell instance $49767 r180 *1 3884.78,2020.1
X$49767 \$18 \$2724 \$2686 VSS INVR03
* cell instance $49770 r180 *1 3916.2,2020.1
X$49770 \$18 \$2724 \$1433 \$2489 VSS AND201
* cell instance $49771 m0 *1 3916.2,2020.1
X$49771 \$18 \$2638 \$2489 VSS INVR02
* cell instance $49772 r180 *1 3949.8,2020.1
X$49772 \$18 \$2550 \$2688 VSS INVR03
* cell instance $49773 m0 *1 3949.8,2020.1
X$49773 \$18 \$2637 \$2688 VSS INVR06
* cell instance $49776 m0 *1 3991.72,2020.1
X$49776 \$2639 \$18 \$2638 VSS INVR01
* cell instance $49778 m0 *1 4008.16,2020.1
X$49778 \$2640 \$18 \$1037 VSS INVR01
* cell instance $49780 m0 *1 4020.76,2020.1
X$49780 \$18 \$758 \$2557 VSS INVR06
* cell instance $49781 r180 *1 4079.56,2020.1
X$49781 \$18 \$2643 \$2644 VSS INVR06
* cell instance $49784 r180 *1 4111.62,2020.1
X$49784 \$18 \$2644 \$1846 \$2639 VSS AND201
* cell instance $49798 m0 *1 4212.76,2020.1
X$49798 \$18 \$2414 \$2210 VSS INVR03
* cell instance $49809 m0 *1 4379,2020.1
X$49809 \$2592 \$18 \$44 VSS INVR05
* cell instance $49811 m0 *1 4412.33,2020.1
X$49811 \$18 \$2228 \$2648 VSS INVR02
* cell instance $49814 m0 *1 4442.34,2020.1
X$49814 \$18 \$2648 \$2650 VSS INVR02
* cell instance $49819 r180 *1 4513.99,2020.1
X$49819 \$2651 \$18 \$2652 \$2618 VSS NOR201
* cell instance $49821 r180 *1 4539.2,2020.1
X$49821 \$18 \$2618 \$2619 \$2656 VSS AND201
* cell instance $49822 m0 *1 4539.2,2020.1
X$49822 \$18 \$2411 \$2424 VSS INVR02
* cell instance $49824 m0 *1 4561.73,2020.1
X$49824 \$18 \$2424 \$2619 VSS INVR02
* cell instance $49828 r180 *1 4613.09,2020.1
X$49828 \$2656 \$2364 \$18 \$2701 VSS OR2101
* cell instance $49832 m0 *1 4706.1,2020.1
X$49832 \$18 \$1134 \$2620 VSS INVR02
* cell instance $49839 r180 *1 4854.45,2020.1
X$49839 \$2559 \$2497 \$2441 \$2284 \$2529 \$18 VSS NND401
* cell instance $49842 m0 *1 4864.5,2020.1
X$49842 \$18 \$2660 \$2707 VSS INVR04
* cell instance $49843 r180 *1 4919.1,2020.1
X$49843 \$2661 \$18 \$2529 \$2441 VSS NOR201
* cell instance $49846 m0 *1 4931.17,2020.1
X$49846 \$18 \$2437 \$2570 VSS INVR02
* cell instance $49848 m0 *1 4956.84,2020.1
X$49848 \$2710 \$2631 \$18 \$2598 VSS OR2101
* cell instance $49851 m0 *1 4994.49,2020.1
X$49851 \$18 \$1041 \$2711 VSS INVR06
* cell instance $49852 m0 *1 5023.89,2020.1
X$49852 \$18 \$2599 \$2712 VSS INVR03
* cell instance $49854 m0 *1 5049.06,2020.1
X$49854 \$18 \$2626 \$2713 VSS INVR03
* cell instance $49855 m0 *1 5065.86,2020.1
X$49855 \$18 \$2573 \$2733 VSS INVR03
* cell instance $49856 m0 *1 5082.66,2020.1
X$49856 \$18 \$2626 \$2733 VSS INVR06
* cell instance $49857 m0 *1 5112.06,2020.1
X$49857 \$18 \$2669 \$2713 VSS INVR06
* cell instance $49860 m0 *1 5148.87,2020.1
X$49860 \$2559 \$18 \$2598 VSS INVR05
* cell instance $49862 m0 *1 5174.07,2020.1
X$49862 \$18 \$2718 \$2824 VSS INVR02
* cell instance $49945 m0 *1 5840.77,2020.1
X$49945 \$18 \$2670 \$2719 VSS INVR06
* cell instance $49946 m0 *1 5870.17,2020.1
X$49946 \$18 \$1715 \$2672 VSS INVR02
* cell instance $50322 m0 *1 3994.2,1665.3
X$50322 \$18 \$1820 \$2121 VSS INVR02
* cell instance $50323 m0 *1 4011.6,1665.3
X$50323 \$18 \$2123 \$2122 VSS INVR06
* cell instance $50324 r180 *1 4066.2,1665.3
X$50324 \$18 \$2124 \$2125 \$2126 VSS AND201
* cell instance $50326 m0 *1 4071,1665.3
X$50326 \$18 \$1946 \$2127 VSS INVR02
* cell instance $50330 r180 *1 4140.37,1665.3
X$50330 \$2070 \$1981 \$1918 \$18 VSS XNR201
* cell instance $50331 m0 *1 4140.37,1665.3
X$50331 \$18 \$1238 \$2128 VSS INVR06
* cell instance $50334 m0 *1 4182.98,1665.3
X$50334 \$18 \$1976 \$2072 VSS INVR02
* cell instance $50336 r180 *1 4237.58,1665.3
X$50336 \$2072 \$2130 \$2126 \$18 VSS XNR201
* cell instance $50339 r180 *1 4260.63,1665.3
X$50339 \$18 \$1983 \$2070 VSS INVR02
* cell instance $50342 m0 *1 4271.49,1665.3
X$50342 \$2132 \$18 \$1238 VSS INVR05
* cell instance $50344 m0 *1 4299.23,1665.3
X$50344 \$18 \$2180 \$2074 VSS INVR03
* cell instance $50345 m0 *1 4316.03,1665.3
X$50345 \$18 \$2133 \$2134 VSS INVR02
* cell instance $50346 m0 *1 4334.58,1665.3
X$50346 \$18 \$2135 \$2136 VSS INVR03
* cell instance $50350 m0 *1 4362.83,1665.3
X$50350 \$18 \$1949 \$2180 VSS INVR03
* cell instance $50357 r180 *1 4432.39,1665.3
X$50357 \$2076 \$2138 \$18 \$2323 VSS OR2101
* cell instance $50359 m0 *1 4432.39,1665.3
X$50359 \$2140 \$18 \$2183 VSS INVR05
* cell instance $50362 r180 *1 4514.89,1665.3
X$50362 \$2143 \$1952 \$2138 \$2141 \$2077 \$2132 \$18 VSS NND501
* cell instance $50365 m0 *1 4525.32,1665.3
X$50365 \$2076 \$18 \$2187 VSS INVR01
* cell instance $50366 m0 *1 4537.92,1665.3
X$50366 \$18 \$2145 \$1955 VSS INVR02
* cell instance $50367 r180 *1 4592.53,1665.3
X$50367 \$2143 \$18 \$1956 \$2148 \$1955 VSS NND301
* cell instance $50371 m0 *1 4607.99,1665.3
X$50371 \$1614 \$18 \$1952 VSS INVR05
* cell instance $50374 m0 *1 4641.59,1665.3
X$50374 \$18 \$1830 \$1834 VSS INVR03
* cell instance $50380 m0 *1 4699.14,1665.3
X$50380 \$18 \$2132 \$2005 VSS INVR02
* cell instance $50382 m0 *1 4718.4,1665.3
X$50382 \$18 \$2188 \$2242 VSS INVR02
* cell instance $50383 m0 *1 4735.2,1665.3
X$50383 \$18 \$2002 \$1999 VSS INVR02
* cell instance $50384 r180 *1 4768.8,1665.3
X$50384 \$18 \$2154 \$2188 VSS INVR02
* cell instance $50386 m0 *1 4772.91,1665.3
X$50386 \$18 \$1149 \$1832 VSS INVR03
* cell instance $50387 r180 *1 4802.31,1665.3
X$50387 \$1998 \$18 \$1959 VSS INVR01
* cell instance $50391 r180 *1 4833.64,1665.3
X$50391 \$18 \$1962 \$2004 VSS INVR02
* cell instance $50393 m0 *1 4843.74,1665.3
X$50393 \$2092 \$18 \$1962 \$2156 \$1963 VSS AND301
* cell instance $50397 m0 *1 4888.17,1665.3
X$50397 \$18 \$2095 \$2010 \$2004 VSS AND201
* cell instance $50400 m0 *1 4923.59,1665.3
X$50400 \$2160 \$18 \$2092 \$2095 VSS NOR201
* cell instance $50404 m0 *1 4971.64,1665.3
X$50404 \$18 \$1859 \$2161 VSS INVR03
* cell instance $50427 m0 *1 5289.92,1665.3
X$50427 \$18 \$1719 \$1867 VSS INVR02
* cell instance $50432 m0 *1 5340.03,1665.3
X$50432 \$18 \$2166 \$2167 VSS INVR03
* cell instance $50435 m0 *1 5358.93,1665.3
X$50435 \$18 \$1968 \$2167 VSS INVR06
* cell instance $50874 m0 *1 86.67,4148.9
X$50874 \$18 \$9196 \$9417 VSS INVR06
* cell instance $50879 m0 *1 149.53,4148.9
X$50879 \$18 \$9418 \$9419 VSS INVR03
* cell instance $50881 r180 *1 178.93,4148.9
X$50881 \$8812 \$18 \$8528 VSS INVR01
* cell instance $50882 r180 *1 225.13,4148.9
X$50882 \$9424 \$9422 \$9421 \$9425 \$9423 \$18 VSS AOI401
* cell instance $50885 m0 *1 236.01,4148.9
X$50885 \$18 \$9097 \$9426 VSS INVR06
* cell instance $50886 m0 *1 265.42,4148.9
X$50886 \$7686 \$7489 \$9092 \$8534 \$7859 \$18 VSS NND401
* cell instance $50887 m0 *1 311.62,4148.9
X$50887 \$18 \$9428 \$5728 VSS INVR06
* cell instance $50890 m0 *1 344.06,4148.9
X$50890 \$9431 \$18 \$9652 \$6777 VSS NOR201
* cell instance $50891 m0 *1 378.27,4148.9
X$50891 \$9429 \$9432 \$18 \$9430 VSS OR2101
* cell instance $50892 m0 *1 399.27,4148.9
X$50892 \$18 \$9430 \$9654 \$9433 VSS AND201
* cell instance $50896 m0 *1 438.71,4148.9
X$50896 \$18 \$9436 \$9300 \$8526 VSS AND201
* cell instance $50898 m0 *1 468.72,4148.9
X$50898 \$9437 \$18 \$8918 \$8960 \$9436 VSS ADNR01
* cell instance $50905 r180 *1 553.93,4148.9
X$50905 \$18 \$8966 \$9438 VSS INVR03
* cell instance $50907 r180 *1 583.34,4148.9
X$50907 \$18 \$9300 \$9438 VSS INVR06
* cell instance $50908 m0 *1 583.34,4148.9
X$50908 \$18 \$9437 \$9442 VSS INVR02
* cell instance $50909 m0 *1 602.23,4148.9
X$50909 \$9444 \$18 \$9443 VSS INVR01
* cell instance $50912 r180 *1 640.27,4148.9
X$50912 \$18 \$8967 \$8964 VSS INVR03
* cell instance $50913 m0 *1 640.27,4148.9
X$50913 \$9300 \$9299 \$9446 \$18 VSS PDDR04
* cell instance $50915 r180 *1 734.03,4148.9
X$50915 \$9449 \$9301 \$18 \$9446 VSS OR2101
* cell instance $50917 m0 *1 734.03,4148.9
X$50917 \$18 \$9301 \$9450 VSS INVR02
* cell instance $50918 r180 *1 763.43,4148.9
X$50918 \$9449 \$18 \$9452 VSS INVR01
* cell instance $50919 r180 *1 780.23,4148.9
X$50919 \$18 \$10201 \$9453 VSS INVR02
* cell instance $50922 m0 *1 797.21,4148.9
X$50922 \$5916 \$18 \$9454 VSS INVR05
* cell instance $50925 m0 *1 832.94,4148.9
X$50925 \$18 \$9455 \$8147 \$8834 VSS AND201
* cell instance $50926 m0 *1 858.14,4148.9
X$50926 \$18 \$9456 \$9457 VSS INVR03
* cell instance $50929 m0 *1 886.91,4148.9
X$50929 \$18 \$9305 \$9460 VSS INVR03
* cell instance $50931 m0 *1 903.71,4148.9
X$50931 \$18 \$9461 \$9305 VSS INVR02
* cell instance $50933 m0 *1 929.53,4148.9
X$50933 \$18 \$9205 \$8532 VSS INVR03
* cell instance $50935 m0 *1 946.33,4148.9
X$50935 \$18 \$8550 \$8976 VSS INVR02
* cell instance $50936 m0 *1 963.15,4148.9
X$50936 \$9461 \$18 \$8418 \$8532 VSS NOR201
* cell instance $50943 m0 *1 1039.96,4148.9
X$50943 \$18 \$9464 \$8548 VSS INVR03
* cell instance $50946 m0 *1 1062.37,4148.9
X$50946 \$18 \$9466 \$9467 VSS INVR03
* cell instance $50948 m0 *1 1179.97,4148.9
X$50948 \$18 \$9310 \$9466 VSS INVR06
* cell instance $50951 r180 *1 1248.99,4148.9
X$50951 \$9206 \$18 \$9472 \$9471 VSS NOR201
* cell instance $50953 r180 *1 1277.04,4148.9
X$50953 \$18 \$9471 \$9105 \$9210 VSS AND201
* cell instance $50954 r180 *1 1293.84,4148.9
X$50954 \$18 \$9206 \$9668 VSS INVR03
* cell instance $50955 r180 *1 1310.64,4148.9
X$50955 \$18 \$8751 \$8843 VSS INVR03
* cell instance $50957 m0 *1 1315.82,4148.9
X$50957 \$18 \$9208 \$9468 VSS INVR03
* cell instance $50960 m0 *1 1335.47,4148.9
X$50960 \$9210 \$9477 \$18 \$9669 VSS OR2101
* cell instance $50961 m0 *1 1356.48,4148.9
X$50961 \$18 \$8162 \$9208 VSS INVR02
* cell instance $50963 m0 *1 1381.79,4148.9
X$50963 \$18 \$8983 \$8985 VSS INVR02
* cell instance $50964 m0 *1 1398.59,4148.9
X$50964 \$18 \$9480 \$9481 VSS INVR03
* cell instance $50965 m0 *1 1415.39,4148.9
X$50965 \$18 \$9481 \$8729 VSS INVR02
* cell instance $50966 m0 *1 1432.19,4148.9
X$50966 \$7500 \$18 \$9480 VSS INVR05
* cell instance $50967 m0 *1 1457.39,4148.9
X$50967 \$18 \$9482 \$9480 VSS INVR03
* cell instance $50978 m0 *1 1549.66,4148.9
X$50978 \$18 \$9104 \$9485 VSS INVR03
* cell instance $50980 r180 *1 1583.26,4148.9
X$50980 \$9315 \$9486 \$9485 \$18 VSS NND201
* cell instance $50981 m0 *1 1583.27,4148.9
X$50981 \$9488 \$18 \$9487 VSS INVR01
* cell instance $50986 m0 *1 1625.94,4148.9
X$50986 \$9316 \$9486 \$9485 \$18 VSS NND201
* cell instance $50988 m0 *1 1642.74,4148.9
X$50988 \$18 \$9910 \$9317 VSS INVR02
* cell instance $50989 m0 *1 1659.54,4148.9
X$50989 \$18 \$9317 \$9630 VSS INVR02
* cell instance $50990 m0 *1 1676.34,4148.9
X$50990 \$18 \$9630 \$7529 VSS INVR03
* cell instance $50993 m0 *1 1703.59,4148.9
X$50993 \$18 \$9318 \$8990 VSS INVR02
* cell instance $50994 m0 *1 1720.39,4148.9
X$50994 \$18 \$9492 \$9491 VSS INVR06
* cell instance $50998 r180 *1 1794.12,4148.9
X$50998 \$18 \$9318 \$9108 \$9323 VSS AND201
* cell instance $51001 m0 *1 1799.5,4148.9
X$51001 \$18 \$8992 \$9108 VSS INVR02
* cell instance $51005 m0 *1 1828.09,4148.9
X$51005 \$8857 \$18 \$8856 VSS INVR05
* cell instance $51008 r180 *1 1876.4,4148.9
X$51008 \$7907 \$9323 \$18 \$9495 VSS OR2101
* cell instance $51015 m0 *1 1916.05,4148.9
X$51015 \$18 \$9497 \$8035 VSS INVR03
* cell instance $51017 m0 *1 1932.85,4148.9
X$51017 \$18 \$9324 \$9497 VSS INVR02
* cell instance $51018 r180 *1 1974.85,4148.9
X$51018 \$18 \$9324 \$8586 \$8999 VSS AND201
* cell instance $51019 m0 *1 1976.63,4148.9
X$51019 \$18 \$9215 \$9499 VSS INVR02
* cell instance $51024 m0 *1 2005.08,4148.9
X$51024 \$18 \$9000 \$7909 VSS INVR06
* cell instance $51025 m0 *1 2034.48,4148.9
X$51025 \$18 \$9501 \$8587 VSS INVR02
* cell instance $51029 r180 *1 2082.42,4148.9
X$51029 \$18 \$9503 \$9502 VSS INVR03
* cell instance $51030 m0 *1 2082.42,4148.9
X$51030 \$8185 \$18 \$9000 VSS INVR05
* cell instance $51032 m0 *1 2109.73,4148.9
X$51032 \$18 \$9505 \$9502 VSS INVR04
* cell instance $51034 m0 *1 2140.48,4148.9
X$51034 \$18 \$9115 \$9111 VSS INVR02
* cell instance $51040 m0 *1 2180.83,4148.9
X$51040 \$18 \$8592 \$8593 VSS INVR03
* cell instance $51042 m0 *1 2198.83,4148.9
X$51042 \$18 \$9116 \$10224 VSS INVR03
* cell instance $51045 m0 *1 2270.23,4148.9
X$51045 \$18 \$9511 \$9510 VSS INVR06
* cell instance $51047 m0 *1 2308.79,4148.9
X$51047 \$9512 \$6833 \$18 \$9685 VSS OR2101
* cell instance $51049 r180 *1 2346.6,4148.9
X$51049 \$18 \$6916 \$9686 VSS INVR03
* cell instance $51051 m0 *1 2349.85,4148.9
X$51051 \$9514 \$18 \$10224 VSS INVR05
* cell instance $51054 m0 *1 2377.83,4148.9
X$51054 \$18 \$9220 \$8185 VSS INVR06
* cell instance $51055 r180 *1 2424.03,4148.9
X$51055 \$9117 \$9121 \$8184 \$18 VSS NND201
* cell instance $51057 r180 *1 2454.04,4148.9
X$51057 \$18 \$9515 \$9121 \$9007 VSS AND201
* cell instance $51060 m0 *1 2464.62,4148.9
X$51060 \$18 \$8769 \$8597 VSS INVR06
* cell instance $51064 m0 *1 2505.85,4148.9
X$51064 \$9223 \$18 \$9796 \$9220 VSS NOR201
* cell instance $51065 m0 *1 2539.45,4148.9
X$51065 \$18 \$7563 \$9519 VSS INVR03
* cell instance $51066 m0 *1 2556.25,4148.9
X$51066 \$18 \$9223 \$7572 VSS INVR02
* cell instance $51068 r180 *1 2603.05,4148.9
X$51068 \$8772 \$9798 \$18 \$9691 VSS OR2101
* cell instance $51072 m0 *1 2609.95,4148.9
X$51072 \$18 \$9519 \$9523 VSS INVR03
* cell instance $51073 r180 *1 2643.55,4148.9
X$51073 \$18 \$7572 \$9524 VSS INVR02
* cell instance $51076 m0 *1 2657.36,4148.9
X$51076 \$18 \$8206 \$9526 VSS INVR03
* cell instance $51078 m0 *1 2674.16,4148.9
X$51078 \$18 \$8875 \$9527 VSS INVR02
* cell instance $51080 r180 *1 2718,4148.9
X$51080 \$18 \$9014 \$9697 \$9016 VSS AND201
* cell instance $51082 m0 *1 2721.18,4148.9
X$51082 \$18 \$9226 \$9800 VSS INVR02
* cell instance $51084 m0 *1 2737.98,4148.9
X$51084 \$9226 \$9698 \$9528 \$18 VSS NND201
* cell instance $51085 m0 *1 2754.78,4148.9
X$51085 \$9528 \$18 \$9018 VSS INVR01
* cell instance $51086 r180 *1 2800.98,4148.9
X$51086 \$9228 \$18 \$7925 \$8691 VSS NOR201
* cell instance $51088 r180 *1 2820.44,4148.9
X$51088 \$18 \$9228 \$8212 VSS INVR02
* cell instance $51090 m0 *1 2829.32,4148.9
X$51090 \$18 \$8212 \$9646 VSS INVR02
* cell instance $51091 m0 *1 2848.22,4148.9
X$51091 \$18 \$9646 \$8881 VSS INVR03
* cell instance $51095 r180 *1 2894.43,4148.9
X$51095 \$9024 \$9529 \$9534 \$18 VSS NND201
* cell instance $51096 m0 *1 2894.66,4148.9
X$51096 \$18 \$9027 \$9529 VSS INVR02
* cell instance $51097 m0 *1 2911.46,4148.9
X$51097 \$18 \$9531 \$8872 VSS INVR04
* cell instance $51101 m0 *1 2940.27,4148.9
X$51101 \$18 \$9532 \$8268 VSS INVR06
* cell instance $51102 r180 *1 2990.67,4148.9
X$51102 \$9531 \$8613 \$18 \$8614 VSS OR2101
* cell instance $51103 m0 *1 2990.67,4148.9
X$51103 \$18 \$8611 \$9534 VSS INVR02
* cell instance $51105 m0 *1 3012.24,4148.9
X$51105 \$18 \$8205 \$9028 VSS INVR03
* cell instance $51110 m0 *1 3048.43,4148.9
X$51110 \$18 \$9536 \$9097 VSS INVR06
* cell instance $51113 m0 *1 3084.44,4148.9
X$51113 \$18 \$9342 \$9538 VSS INVR03
* cell instance $51116 r180 *1 3125.79,4148.9
X$51116 \$18 \$8617 \$9342 VSS INVR02
* cell instance $51120 r180 *1 3163.15,4148.9
X$51120 \$18 \$8617 \$7719 \$8779 VSS AND201
* cell instance $51122 m0 *1 3167.84,4148.9
X$51122 \$18 \$9523 \$8885 VSS INVR03
* cell instance $51125 m0 *1 3195.52,4148.9
X$51125 \$18 \$9492 \$9542 VSS INVR03
* cell instance $51132 m0 *1 3253.77,4148.9
X$51132 \$18 \$9544 \$9542 VSS INVR06
* cell instance $51139 r180 *1 3341.8,4148.9
X$51139 \$18 \$9545 \$9034 VSS INVR02
* cell instance $51161 r180 *1 3533.67,4148.9
X$51161 \$18 \$9503 \$5481 VSS INVR06
* cell instance $51166 m0 *1 3566.85,4148.9
X$51166 \$18 \$8674 \$9549 VSS INVR02
* cell instance $51257 m0 *1 4386.12,4148.9
X$51257 \$18 \$8619 \$9035 VSS INVR02
* cell instance $51259 m0 *1 4412.37,4148.9
X$51259 \$8743 \$9036 \$9703 \$I331445 \$5484 \$18 VSS DFCL11
* cell instance $51348 m0 *1 5206.89,4148.9
X$51348 \$18 \$10264 \$9553 VSS INVR03
* cell instance $51374 r180 *1 5433.44,4148.9
X$51374 \$18 \$9554 \$9353 VSS INVR02
* cell instance $51375 m0 *1 5433.44,4148.9
X$51375 \$18 \$9353 \$9707 VSS INVR02
* cell instance $51376 m0 *1 5451.83,4148.9
X$51376 \$9556 \$9558 \$9559 \$9555 \$9037 \$18 VSS AOI401
* cell instance $51378 m0 *1 5498.03,4148.9
X$51378 \$10269 \$18 \$9037 VSS INVR05
* cell instance $51381 m0 *1 5535.62,4148.9
X$51381 \$18 \$9554 \$9560 VSS INVR06
* cell instance $51387 r180 *1 5706.93,4148.9
X$51387 \$8743 \$9238 \$9564 \$I331369 \$9040 \$18 VSS DFCL11
* cell instance $51389 m0 *1 5706.93,4148.9
X$51389 \$18 \$9566 \$9554 VSS INVR06
* cell instance $51391 m0 *1 5745.18,4148.9
X$51391 \$8743 \$9238 \$9950 \$I331410 \$9567 \$18 VSS DFCL11
* cell instance $51392 m0 *1 5845.98,4148.9
X$51392 \$18 \$9567 \$9041 VSS INVR02
* cell instance $51393 m0 *1 5863.19,4148.9
X$51393 \$8743 \$9238 \$9809 \$I331418 \$9043 \$18 VSS DFCL11
* cell instance $51394 m0 *1 5964,4148.9
X$51394 \$18 \$9360 \$8620 VSS INVR02
* cell instance $51397 m0 *1 5987.38,4148.9
X$51397 \$18 \$9042 \$9570 VSS INVR03
* cell instance $51399 m0 *1 6012.88,4148.9
X$51399 \$18 \$8464 \$9360 VSS INVR02
* cell instance $51406 m0 *1 6068.34,4148.9
X$51406 \$18 \$9238 \$9713 VSS INVR06
* cell instance $51407 m0 *1 6098.37,4148.9
X$51407 \$18 \$9238 \$8892 VSS INVR03
* cell instance $51408 m0 *1 6115.17,4148.9
X$51408 \$18 \$9573 \$9574 VSS INVR02
* cell instance $51409 m0 *1 6131.97,4148.9
X$51409 \$9576 \$9578 \$9579 \$9575 \$9577 \$18 VSS AOI401
* cell instance $51410 m0 *1 6178.18,4148.9
X$51410 \$18 \$9580 \$9581 VSS INVR02
* cell instance $51416 m0 *1 6225.85,4148.9
X$51416 \$18 \$9582 \$9045 VSS INVR02
* cell instance $51417 m0 *1 6242.65,4148.9
X$51417 \$8743 \$9044 \$8893 \$I331408 \$9047 \$18 VSS DFCL11
* cell instance $51431 m0 *1 6448.14,4148.9
X$51431 \$8743 \$9044 \$9586 \$I331450 \$9587 \$18 VSS DFCL11
* cell instance $51440 m0 *1 6604.64,4148.9
X$51440 \$18 \$9587 \$9368 VSS INVR03
* cell instance $51446 m0 *1 6653.95,4148.9
X$51446 \$18 \$9368 \$8897 VSS INVR03
* cell instance $51469 m0 *1 6837.25,4148.9
X$51469 \$18 \$9590 \$8896 VSS INVR06
* cell instance $51501 m0 *1 7107.76,4148.9
X$51501 \$18 \$9592 \$9566 VSS INVR06
* cell instance $51535 m0 *1 7396.2,4148.9
X$51535 \$18 \$8464 \$9603 VSS INVR03
* cell instance $51538 m0 *1 7415.1,4148.9
X$51538 \$18 \$9049 \$9603 VSS INVR06
* cell instance $51689 m0 *1 8635.2,4148.9
X$51689 \$18 \$9590 \$9594 VSS INVR02
* cell instance $51697 m0 *1 8698.81,4148.9
X$51697 \$18 \$9592 \$9596 VSS INVR03
* cell instance $51704 m0 *1 8761.2,4148.9
X$51704 \$18 \$9050 \$9597 VSS INVR03
* cell instance $51722 m0 *1 94.2,3616.7
X$51722 \$18 \$7034 \$6766 VSS INVR02
* cell instance $51726 m0 *1 124.84,3616.7
X$51726 \$18 \$6726 \$6768 VSS INVR06
* cell instance $51727 m0 *1 255.04,3616.7
X$51727 \$7329 \$18 \$7246 VSS INVR05
* cell instance $51729 m0 *1 285.05,3616.7
X$51729 \$18 \$6479 \$7123 VSS INVR06
* cell instance $51730 m0 *1 314.45,3616.7
X$51730 \$18 \$6595 \$7247 VSS INVR03
* cell instance $51736 m0 *1 562.88,3616.7
X$51736 \$7131 \$18 \$7087 VSS INVR05
* cell instance $51738 r180 *1 613.21,3616.7
X$51738 \$18 \$7088 \$7133 VSS INVR03
* cell instance $51739 m0 *1 613.21,3616.7
X$51739 \$18 \$7133 \$7087 VSS INVR03
* cell instance $51740 m0 *1 630.01,3616.7
X$51740 \$7134 \$7088 \$6250 \$18 VSS XNR201
* cell instance $51745 m0 *1 690.46,3616.7
X$51745 \$18 \$7335 \$6332 \$7401 VSS AND201
* cell instance $51746 m0 *1 715.66,3616.7
X$51746 \$18 \$6859 \$6791 VSS INVR02
* cell instance $51751 m0 *1 800.26,3616.7
X$51751 \$18 \$6772 \$7047 VSS INVR02
* cell instance $51754 m0 *1 824.06,3616.7
X$51754 \$18 \$6861 \$7260 VSS INVR03
* cell instance $51763 m0 *1 918.34,3616.7
X$51763 \$18 \$7047 \$6523 VSS INVR02
* cell instance $51767 r180 *1 967.27,3616.7
X$51767 \$7147 \$7139 \$18 \$7261 VSS OR2101
* cell instance $51769 m0 *1 967.27,3616.7
X$51769 \$6870 \$7024 \$18 \$6523 VSS OR2101
* cell instance $51772 m0 *1 999.55,3616.7
X$51772 \$18 \$7023 \$7154 VSS INVR03
* cell instance $51774 r180 *1 1037.35,3616.7
X$51774 \$7106 \$6607 \$18 \$7261 VSS OR2101
* cell instance $51775 m0 *1 1037.35,3616.7
X$51775 \$18 \$6615 \$7023 VSS INVR02
* cell instance $51777 r180 *1 1080.77,3616.7
X$51777 \$18 \$7147 \$6677 \$7024 VSS AND201
* cell instance $51778 r180 *1 1093.38,3616.7
X$51778 \$7151 \$18 \$6622 VSS INVR01
* cell instance $51780 r180 *1 1120.19,3616.7
X$51780 \$18 \$7106 \$7151 \$6677 VSS AND201
* cell instance $51781 r180 *1 1155,3616.7
X$51781 \$7152 \$18 \$4983 \$6733 VSS NOR201
* cell instance $51786 m0 *1 1175.85,3616.7
X$51786 \$5420 \$7154 \$6617 \$6342 \$6882 \$18 VSS AND401
* cell instance $51788 m0 *1 1218.14,3616.7
X$51788 \$18 \$6879 \$7343 VSS INVR03
* cell instance $51791 r180 *1 1261.9,3616.7
X$51791 \$18 \$6980 \$6979 VSS INVR02
* cell instance $51794 m0 *1 1274.5,3616.7
X$51794 \$18 \$7053 \$7274 VSS INVR03
* cell instance $51797 m0 *1 1303.9,3616.7
X$51797 \$18 \$6616 \$7157 VSS INVR06
* cell instance $51798 m0 *1 1333.3,3616.7
X$51798 \$18 \$7054 \$7274 VSS INVR06
* cell instance $51799 m0 *1 1364.51,3616.7
X$51799 \$18 \$7277 \$7055 VSS INVR03
* cell instance $51801 m0 *1 1381.31,3616.7
X$51801 \$18 \$7158 \$7423 \$7348 VSS AND201
* cell instance $51802 m0 *1 1406.51,3616.7
X$51802 \$7055 \$7159 \$18 \$7278 VSS OR2101
* cell instance $51803 m0 *1 1427.51,3616.7
X$51803 \$18 \$7158 \$7053 VSS INVR03
* cell instance $51806 m0 *1 1455.23,3616.7
X$51806 \$18 \$6628 \$6809 VSS INVR03
* cell instance $51809 m0 *1 1477.4,3616.7
X$51809 \$18 \$3066 \$7162 VSS INVR06
* cell instance $51810 m0 *1 1506.8,3616.7
X$51810 \$18 \$7054 \$6626 VSS INVR03
* cell instance $51811 m0 *1 1523.6,3616.7
X$51811 \$18 \$6884 \$7166 VSS INVR02
* cell instance $51813 r180 *1 1574.47,3616.7
X$51813 \$18 \$6890 \$6807 \$6893 VSS AND201
* cell instance $51815 m0 *1 1579.72,3616.7
X$51815 \$18 \$6685 \$6896 \$5255 VSS AND201
* cell instance $51817 m0 *1 1604.92,3616.7
X$51817 \$18 \$7058 \$7168 VSS INVR02
* cell instance $51818 m0 *1 1621.72,3616.7
X$51818 \$7170 \$6885 \$7169 \$18 VSS NND201
* cell instance $51819 r180 *1 1660.86,3616.7
X$51819 \$7171 \$6631 \$18 \$7283 VSS OR2101
* cell instance $51822 r180 *1 1688.07,3616.7
X$51822 \$18 \$7171 \$7172 \$6178 VSS AND201
* cell instance $51824 m0 *1 1692.12,3616.7
X$51824 \$18 \$6816 \$6894 \$7169 VSS AND201
* cell instance $51828 m0 *1 1735.34,3616.7
X$51828 \$18 \$7175 \$7238 VSS INVR02
* cell instance $51829 m0 *1 1752.14,3616.7
X$51829 \$18 \$7238 \$7176 VSS INVR03
* cell instance $51837 m0 *1 1816.56,3616.7
X$51837 \$18 \$6819 \$6894 \$6366 VSS AND201
* cell instance $51840 m0 *1 1847.52,3616.7
X$51840 \$18 \$7180 \$5255 \$6902 VSS AND201
* cell instance $51852 r180 *1 1960.27,3616.7
X$51852 \$18 \$7235 \$6894 VSS INVR03
* cell instance $51854 r180 *1 1980.03,3616.7
X$51854 \$18 \$6823 \$7235 VSS INVR02
* cell instance $51861 m0 *1 2017.91,3616.7
X$51861 \$18 \$6055 \$6825 VSS INVR06
* cell instance $51870 m0 *1 2113.16,3616.7
X$51870 \$18 \$6055 \$7186 VSS INVR03
* cell instance $51872 m0 *1 2129.96,3616.7
X$51872 \$7187 \$7188 \$6832 \$18 VSS XNR201
* cell instance $51885 m0 *1 2355.11,3616.7
X$51885 \$18 \$7193 \$7194 VSS INVR03
* cell instance $51890 m0 *1 2386.95,3616.7
X$51890 \$18 \$7071 \$7195 VSS INVR06
* cell instance $51897 m0 *1 2459.56,3616.7
X$51897 \$18 \$7197 \$7288 VSS INVR03
* cell instance $51899 m0 *1 2476.36,3616.7
X$51899 \$18 \$7198 \$7199 VSS INVR02
* cell instance $51902 m0 *1 2510.32,3616.7
X$51902 \$6918 \$7071 \$7220 \$18 VSS XNR201
* cell instance $51931 m0 *1 2805.09,3616.7
X$51931 \$18 \$7203 \$6736 VSS INVR06
* cell instance $52083 m0 *1 4032,3616.7
X$52083 \$18 \$7205 \$3257 VSS INVR06
* cell instance $52095 m0 *1 4132.56,3616.7
X$52095 \$18 \$7073 \$3259 VSS INVR06
* cell instance $52096 m0 *1 4161.96,3616.7
X$52096 \$18 \$6837 \$7291 VSS INVR06
* cell instance $52138 r180 *1 4550.15,3616.7
X$52138 \$18 \$7206 \$3450 VSS INVR06
* cell instance $52421 m0 *1 6793.12,3616.7
X$52421 \$18 \$5948 \$7293 VSS INVR03
* cell instance $52423 m0 *1 6812.02,3616.7
X$52423 \$18 \$6993 \$7293 VSS INVR06
* cell instance $52426 m0 *1 6852.95,3616.7
X$52426 \$18 \$5795 \$7210 VSS INVR03
* cell instance $52430 m0 *1 6882.35,3616.7
X$52430 \$18 \$7074 \$7210 VSS INVR06
* cell instance $52436 m0 *1 6945.8,3616.7
X$52436 \$7292 \$18 \$4859 VSS INVR05
* cell instance $52540 m0 *1 7795.44,3616.7
X$52540 \$18 \$7214 \$6993 VSS INVR06
* cell instance $52541 m0 *1 7824.84,3616.7
X$52541 \$18 \$7216 \$6385 VSS INVR06
* cell instance $52658 m0 *1 8776.94,3616.7
X$52658 \$18 \$7074 \$7218 VSS INVR02
* cell instance $52672 m0 *1 291.53,2374.9
X$52672 \$18 \$3391 \$3133 VSS INVR02
* cell instance $52682 m0 *1 364.2,2374.9
X$52682 \$18 \$3565 \$3211 VSS INVR02
* cell instance $52684 m0 *1 386.07,2374.9
X$52684 \$3393 \$18 \$3392 VSS INVR05
* cell instance $52695 m0 *1 483.53,2374.9
X$52695 \$18 \$3348 \$3394 VSS INVR03
* cell instance $52706 r180 *1 680.62,2374.9
X$52706 \$18 \$3396 \$3215 \$3397 VSS AND201
* cell instance $52713 m0 *1 723.82,2374.9
X$52713 \$18 \$3394 \$3221 VSS INVR02
* cell instance $52717 r180 *1 772.62,2374.9
X$52717 \$18 \$3295 \$3215 \$3220 VSS AND201
* cell instance $52719 m0 *1 781.42,2374.9
X$52719 \$18 \$3401 \$3402 VSS INVR03
* cell instance $52722 m0 *1 814.42,2374.9
X$52722 \$18 \$2975 \$3483 VSS INVR02
* cell instance $52725 m0 *1 841.71,2374.9
X$52725 \$18 \$3483 \$3065 VSS INVR03
* cell instance $52727 m0 *1 863.28,2374.9
X$52727 \$3136 \$3403 \$18 \$3569 \$3506 VSS NOR301
* cell instance $52733 m0 *1 932.13,2374.9
X$52733 \$18 \$3404 \$3405 VSS INVR02
* cell instance $52735 m0 *1 950.64,2374.9
X$52735 \$3136 \$18 \$3405 VSS INVR05
* cell instance $52739 m0 *1 981.78,2374.9
X$52739 \$18 \$3355 \$3570 VSS INVR02
* cell instance $52742 m0 *1 1005.85,2374.9
X$52742 \$18 \$3355 \$3407 \$3406 VSS AND201
* cell instance $52775 m0 *1 1275.85,2374.9
X$52775 \$18 \$3408 \$2977 VSS INVR06
* cell instance $52785 m0 *1 1379.05,2374.9
X$52785 \$18 \$3409 \$3356 VSS INVR02
* cell instance $52790 m0 *1 1486.83,2374.9
X$52790 \$18 \$3410 \$3487 VSS INVR02
* cell instance $52792 m0 *1 1503.63,2374.9
X$52792 \$18 \$3487 \$3411 VSS INVR03
* cell instance $52795 r180 *1 1571.74,2374.9
X$52795 \$3359 \$3233 \$3358 \$18 VSS XNR201
* cell instance $52799 m0 *1 1578.08,2374.9
X$52799 \$18 \$3233 \$3360 VSS INVR02
* cell instance $52801 r180 *1 1613.63,2374.9
X$52801 \$18 \$3360 \$3414 VSS INVR02
* cell instance $52802 m0 *1 1613.63,2374.9
X$52802 \$18 \$3416 \$3415 VSS INVR06
* cell instance $52805 m0 *1 1649.54,2374.9
X$52805 \$3361 \$18 \$3414 VSS INVR01
* cell instance $52809 m0 *1 1680.34,2374.9
X$52809 \$3359 \$3238 \$18 \$3361 VSS OR2101
* cell instance $52811 m0 *1 1711.41,2374.9
X$52811 \$3236 \$3420 \$3421 \$18 VSS XNR201
* cell instance $52816 m0 *1 1768.21,2374.9
X$52816 \$18 \$3422 \$3415 VSS INVR03
* cell instance $52818 r180 *1 1822.81,2374.9
X$52818 \$3362 \$2836 \$2982 \$18 VSS XNR201
* cell instance $52821 m0 *1 1836.28,2374.9
X$52821 \$3236 \$2927 \$18 \$3517 VSS OR2101
* cell instance $52825 m0 *1 1870.67,2374.9
X$52825 \$3236 \$3362 \$18 \$3653 VSS OR2101
* cell instance $52828 m0 *1 1901.21,2374.9
X$52828 \$3573 \$18 \$2836 VSS INVR01
* cell instance $52834 m0 *1 1936.69,2374.9
X$52834 \$18 \$3427 \$3575 VSS INVR03
* cell instance $52835 m0 *1 1953.49,2374.9
X$52835 \$18 \$3428 \$3494 VSS INVR02
* cell instance $52836 m0 *1 1970.29,2374.9
X$52836 \$18 \$3494 \$3429 VSS INVR03
* cell instance $52845 r180 *1 2068.89,2374.9
X$52845 \$18 \$3241 \$3240 VSS INVR03
* cell instance $52853 r180 *1 2120.79,2374.9
X$52853 \$3522 \$18 \$3108 VSS INVR01
* cell instance $52857 m0 *1 2133.18,2374.9
X$52857 \$3250 \$18 \$3522 VSS INVR01
* cell instance $52870 m0 *1 2269.84,2374.9
X$52870 \$18 \$3432 \$3433 VSS INVR03
* cell instance $52872 r180 *1 2324.44,2374.9
X$52872 \$3434 \$18 \$3436 \$3435 \$2992 VSS NND301
* cell instance $52874 m0 *1 2333.1,2374.9
X$52874 \$18 \$3251 \$3077 VSS INVR02
* cell instance $52876 m0 *1 2404.5,2374.9
X$52876 \$18 \$3255 \$2993 VSS INVR02
* cell instance $53065 r180 *1 3951.31,2374.9
X$53065 \$18 \$2930 \$1566 \$2843 VSS AND201
* cell instance $53097 m0 *1 4193.7,2374.9
X$53097 \$18 \$3443 \$3082 VSS INVR02
* cell instance $53098 m0 *1 4210.5,2374.9
X$53098 \$18 \$2350 \$3440 VSS INVR06
* cell instance $53100 r180 *1 4259.83,2374.9
X$53100 \$18 \$3439 \$3369 VSS INVR03
* cell instance $53102 m0 *1 4259.83,2374.9
X$53102 \$3440 \$18 \$3369 VSS INVR05
* cell instance $53109 r180 *1 4402.68,2374.9
X$53109 \$3373 \$3176 \$3443 \$18 VSS XNR201
* cell instance $53113 m0 *1 4412.69,2374.9
X$53113 \$18 \$3445 \$3485 VSS INVR02
* cell instance $53116 m0 *1 4435.95,2374.9
X$53116 \$18 \$3485 \$2905 VSS INVR02
* cell instance $53119 m0 *1 4466.03,2374.9
X$53119 \$18 \$3016 \$3370 VSS INVR02
* cell instance $53121 m0 *1 4482.83,2374.9
X$53121 \$3448 \$18 \$3016 VSS INVR01
* cell instance $53123 m0 *1 4499.96,2374.9
X$53123 \$18 \$3450 \$3264 VSS INVR06
* cell instance $53125 m0 *1 4539.3,2374.9
X$53125 \$18 \$3453 \$3452 \$2942 VSS AND201
* cell instance $53127 r180 *1 4581.3,2374.9
X$53127 \$18 \$2861 \$3024 VSS INVR02
* cell instance $53130 m0 *1 4592.57,2374.9
X$53130 \$3016 \$3456 \$18 \$3453 VSS OR2101
* cell instance $53134 m0 *1 4627.32,2374.9
X$53134 \$3016 \$3459 \$18 \$3265 VSS OR2101
* cell instance $53137 m0 *1 4654.23,2374.9
X$53137 \$2859 \$3376 \$18 \$3460 \$3090 VSS NOR301
* cell instance $53139 m0 *1 4692.03,2374.9
X$53139 \$3032 \$18 \$3460 VSS INVR05
* cell instance $53140 m0 *1 4717.23,2374.9
X$53140 \$18 \$3464 \$2528 VSS INVR02
* cell instance $53144 m0 *1 4745.95,2374.9
X$53144 \$3326 \$18 \$3376 \$3465 VSS NOR201
* cell instance $53145 m0 *1 4779.55,2374.9
X$53145 \$18 \$2754 \$3270 VSS INVR02
* cell instance $53146 r180 *1 4813.15,2374.9
X$53146 \$18 \$3379 \$3468 VSS INVR02
* cell instance $53147 m0 *1 4914.22,2374.9
X$53147 \$18 \$2502 \$3472 VSS INVR06
* cell instance $53148 m0 *1 4943.62,2374.9
X$53148 \$18 \$3312 \$3473 VSS INVR02
* cell instance $53642 m0 *1 66.86,3439.3
X$53642 \$6586 \$18 \$3208 VSS INVR05
* cell instance $53645 m0 *1 105.27,3439.3
X$53645 \$18 \$6450 \$6223 VSS INVR03
* cell instance $53656 m0 *1 184.8,3439.3
X$53656 \$18 \$6588 \$6507 VSS INVR02
* cell instance $53657 m0 *1 201.6,3439.3
X$53657 \$18 \$6589 \$6590 VSS INVR02
* cell instance $53658 m0 *1 218.4,3439.3
X$53658 \$6508 \$5984 \$18 \$6312 VSS OR2101
* cell instance $53660 m0 *1 249,3439.3
X$53660 \$6508 \$18 \$5983 VSS INVR01
* cell instance $53662 m0 *1 261.6,3439.3
X$53662 \$18 \$6235 \$5728 VSS INVR03
* cell instance $53663 m0 *1 278.4,3439.3
X$53663 \$18 \$6592 \$6593 VSS INVR03
* cell instance $53666 m0 *1 308.4,3439.3
X$53666 \$18 \$6593 \$6595 VSS INVR03
* cell instance $53673 r180 *1 443.16,3439.3
X$53673 \$18 \$6482 \$6598 VSS INVR02
* cell instance $53674 m0 *1 443.16,3439.3
X$53674 \$6479 \$6599 \$6514 \$18 VSS XNR201
* cell instance $53679 m0 *1 547.42,3439.3
X$53679 \$18 \$6601 \$6239 VSS INVR03
* cell instance $53684 m0 *1 590.62,3439.3
X$53684 \$6329 \$5406 \$6207 \$18 VSS NND201
* cell instance $53687 m0 *1 614.39,3439.3
X$53687 \$18 \$6517 \$6332 \$6514 VSS AND201
* cell instance $53690 m0 *1 650.64,3439.3
X$53690 \$18 \$6517 \$6518 VSS INVR02
* cell instance $53692 m0 *1 669.59,3439.3
X$53692 \$18 \$5738 \$5737 VSS INVR03
* cell instance $53702 m0 *1 744.94,3439.3
X$53702 \$18 \$6450 \$6515 VSS INVR06
* cell instance $53711 m0 *1 839.15,3439.3
X$53711 \$18 \$6521 \$6523 \$6607 VSS AND201
* cell instance $53714 m0 *1 877.55,3439.3
X$53714 \$18 \$6522 \$6609 VSS INVR02
* cell instance $53721 m0 *1 1025.46,3439.3
X$53721 \$6258 \$18 \$6612 \$6525 \$6455 VSS ADNR01
* cell instance $53723 m0 *1 1050.66,3439.3
X$53723 \$18 \$6455 \$6268 VSS INVR02
* cell instance $53724 m0 *1 1067.46,3439.3
X$53724 \$6528 \$6525 \$18 \$3227 VSS OR2101
* cell instance $53729 r180 *1 1133.2,3439.3
X$53729 \$18 \$6528 \$6015 \$6677 VSS AND201
* cell instance $53730 r180 *1 1158.41,3439.3
X$53730 \$18 \$6615 \$6616 \$6622 VSS AND201
* cell instance $53734 m0 *1 1172.66,3439.3
X$53734 \$18 \$6617 \$6011 VSS INVR03
* cell instance $53735 m0 *1 1189.46,3439.3
X$53735 \$18 \$6341 \$6343 VSS INVR02
* cell instance $53739 m0 *1 1230.73,3439.3
X$53739 \$18 \$6620 \$5141 \$6268 VSS AND201
* cell instance $53740 m0 *1 1255.94,3439.3
X$53740 \$18 \$6340 \$6274 VSS INVR03
* cell instance $53743 r180 *1 1302.74,3439.3
X$53743 \$18 \$6680 \$6622 VSS INVR03
* cell instance $53748 m0 *1 1327.3,3439.3
X$53748 \$18 \$6272 \$6616 \$6017 VSS AND201
* cell instance $53751 r180 *1 1396.93,3439.3
X$53751 \$6623 \$18 \$6270 \$5753 VSS NOR201
* cell instance $53754 m0 *1 1404.85,3439.3
X$53754 \$18 \$6273 \$6349 VSS INVR03
* cell instance $53756 m0 *1 1421.65,3439.3
X$53756 \$5770 \$6626 \$6627 \$6628 \$6625 \$6274 \$18 VSS NND501
* cell instance $53761 m0 *1 1487.84,3439.3
X$53761 \$18 \$6534 \$5770 VSS INVR06
* cell instance $53763 r180 *1 1626.44,3439.3
X$53763 \$6631 \$6350 \$18 \$6685 VSS OR2101
* cell instance $53764 m0 *1 1626.45,3439.3
X$53764 \$18 \$6467 \$6355 VSS INVR02
* cell instance $53765 m0 *1 1643.25,3439.3
X$53765 \$18 \$5251 \$6175 VSS INVR06
* cell instance $53768 r180 *1 1705.58,3439.3
X$53768 \$6634 \$6632 \$18 \$6360 VSS OR2101
* cell instance $53771 m0 *1 1707.56,3439.3
X$53771 \$18 \$4902 \$6635 VSS INVR06
* cell instance $53773 m0 *1 1740.65,3439.3
X$53773 \$6541 \$6361 \$6687 \$18 VSS NND201
* cell instance $53777 r180 *1 1785.23,3439.3
X$53777 \$18 \$6638 \$6634 VSS INVR02
* cell instance $53779 m0 *1 1794.05,3439.3
X$53779 \$18 \$6640 \$5255 \$6541 VSS AND201
* cell instance $53782 m0 *1 1926,3439.3
X$53782 \$6644 \$6369 \$6640 \$18 \$6367 VSS OR3101
* cell instance $53785 m0 *1 1962.81,3439.3
X$53785 \$18 \$6048 \$6645 VSS INVR02
* cell instance $53793 m0 *1 2034.22,3439.3
X$53793 \$18 \$6547 \$6052 VSS INVR02
* cell instance $53794 m0 *1 2051.02,3439.3
X$53794 \$18 \$6459 \$6547 VSS INVR02
* cell instance $53796 m0 *1 2076.12,3439.3
X$53796 \$18 \$6375 \$5076 VSS INVR02
* cell instance $53798 m0 *1 2097.9,3439.3
X$53798 \$18 \$6052 \$6373 VSS INVR02
* cell instance $53806 m0 *1 2167.66,3439.3
X$53806 \$18 \$6378 \$6648 VSS INVR02
* cell instance $53809 m0 *1 2297.42,3439.3
X$53809 \$18 \$6652 \$6651 VSS INVR06
* cell instance $53813 r180 *1 2374.23,3439.3
X$53813 \$6653 \$18 \$6655 \$6654 VSS NOR201
* cell instance $53951 m0 *1 3471.24,3439.3
X$53951 \$6657 \$18 \$6381 VSS INVR05
* cell instance $54013 m0 *1 3971.87,3439.3
X$54013 \$18 \$6658 \$2840 VSS INVR06
* cell instance $54054 m0 *1 4315.51,3439.3
X$54054 \$18 \$5947 \$6657 VSS INVR06
* cell instance $54055 m0 *1 4344.91,3439.3
X$54055 \$18 \$6661 \$5947 VSS INVR06
* cell instance $54057 m0 *1 4383.39,3439.3
X$54057 \$18 \$6662 \$6554 VSS INVR02
* cell instance $54059 m0 *1 4500.99,3439.3
X$54059 \$18 \$6556 \$6664 VSS INVR03
* cell instance $54060 m0 *1 4517.79,3439.3
X$54060 \$18 \$6554 \$6139 VSS INVR03
* cell instance $54061 m0 *1 4534.59,3439.3
X$54061 \$18 \$2718 \$6664 VSS INVR06
* cell instance $54604 m0 *1 83.04,3794.1
X$54604 \$18 \$4907 \$7856 VSS INVR06
* cell instance $54605 m0 *1 112.44,3794.1
X$54605 \$18 \$7857 \$7760 VSS INVR02
* cell instance $54606 m0 *1 129.24,3794.1
X$54606 \$18 \$5024 \$7856 VSS INVR03
* cell instance $54607 r180 *1 183.84,3794.1
X$54607 \$7859 \$7762 \$7761 \$18 VSS XNR201
* cell instance $54612 m0 *1 257.7,3794.1
X$54612 \$18 \$7765 \$7478 VSS INVR02
* cell instance $54614 m0 *1 274.5,3794.1
X$54614 \$18 \$7329 \$7765 VSS INVR02
* cell instance $54615 r180 *1 333.3,3794.1
X$54615 \$7686 \$7478 \$7477 \$18 VSS XOR201
* cell instance $54617 m0 *1 338.11,3794.1
X$54617 \$7332 \$7247 \$7762 \$7686 \$7769 \$18 VSS AND401
* cell instance $54621 m0 *1 390.42,3794.1
X$54621 \$18 \$7866 \$7867 VSS INVR02
* cell instance $54626 m0 *1 473.74,3794.1
X$54626 \$7489 \$7772 \$7491 \$18 VSS XNR201
* cell instance $54627 r180 *1 536.74,3794.1
X$54627 \$18 \$7770 \$5386 \$5724 VSS AND201
* cell instance $54629 r180 *1 570.94,3794.1
X$54629 \$18 \$7494 \$6482 VSS INVR06
* cell instance $54631 m0 *1 573.39,3794.1
X$54631 \$18 \$7775 \$7779 VSS INVR03
* cell instance $54634 m0 *1 603.39,3794.1
X$54634 \$7744 \$7493 \$7087 \$18 VSS NND201
* cell instance $54639 r180 *1 679.7,3794.1
X$54639 \$7779 \$7778 \$7401 \$18 VSS XNR201
* cell instance $54642 r180 *1 709.71,3794.1
X$54642 \$7780 \$18 \$7872 VSS INVR05
* cell instance $54643 m0 *1 709.71,3794.1
X$54643 \$18 \$7744 \$7775 VSS INVR03
* cell instance $54651 m0 *1 769.71,3794.1
X$54651 \$18 \$7340 \$7594 VSS INVR06
* cell instance $54654 m0 *1 806.83,3794.1
X$54654 \$18 \$7585 \$7408 VSS INVR03
* cell instance $54662 m0 *1 872.91,3794.1
X$54662 \$18 \$7876 \$7784 VSS INVR02
* cell instance $54667 m0 *1 954.7,3794.1
X$54667 \$6967 \$18 \$7784 VSS INVR05
* cell instance $54672 m0 *1 1101.75,3794.1
X$54672 \$18 \$8015 \$7513 VSS INVR03
* cell instance $54675 m0 *1 1125.38,3794.1
X$54675 \$18 \$7512 \$7881 VSS INVR03
* cell instance $54677 m0 *1 1146.39,3794.1
X$54677 \$18 \$7040 \$7882 VSS INVR06
* cell instance $54679 m0 *1 1180.59,3794.1
X$54679 \$6013 \$18 \$7411 VSS INVR05
* cell instance $54682 m0 *1 1218.14,3794.1
X$54682 \$18 \$6870 \$7343 VSS INVR06
* cell instance $54685 m0 *1 1254.55,3794.1
X$54685 \$18 \$7515 \$7348 VSS INVR03
* cell instance $54686 m0 *1 1271.35,3794.1
X$54686 \$18 \$7706 \$6013 \$6616 VSS AND201
* cell instance $54687 r180 *1 1317.56,3794.1
X$54687 \$7706 \$7793 \$18 \$7886 VSS OR2101
* cell instance $54692 m0 *1 1356.56,3794.1
X$54692 \$18 \$7795 \$7888 VSS INVR03
* cell instance $54697 m0 *1 1405.91,3794.1
X$54697 \$7521 \$18 \$7166 \$7423 \$7348 VSS NND301
* cell instance $54698 m0 *1 1443.71,3794.1
X$54698 \$18 \$7888 \$7157 VSS INVR03
* cell instance $54701 m0 *1 1473.06,3794.1
X$54701 \$7277 \$7804 \$18 \$7709 VSS OR2101
* cell instance $54702 m0 *1 1494.06,3794.1
X$54702 \$7894 \$18 \$7804 \$8024 \$5255 VSS AND301
* cell instance $54703 m0 *1 1527.66,3794.1
X$54703 \$18 \$7172 \$7887 VSS INVR06
* cell instance $54704 r180 *1 1573.86,3794.1
X$54704 \$18 \$7709 \$7278 VSS INVR03
* cell instance $54705 r180 *1 1590.66,3794.1
X$54705 \$18 \$6807 \$6884 VSS INVR03
* cell instance $54707 r180 *1 1624.48,3794.1
X$54707 \$18 \$7809 \$7709 \$4902 VSS AND201
* cell instance $54708 m0 *1 1624.48,3794.1
X$54708 \$18 \$7810 \$7900 VSS INVR03
* cell instance $54711 m0 *1 1654.8,3794.1
X$54711 \$6635 \$18 \$7172 VSS INVR05
* cell instance $54723 r180 *1 1767.02,3794.1
X$54723 \$18 \$7812 \$7431 VSS INVR02
* cell instance $54726 r180 *1 1795.61,3794.1
X$54726 \$18 \$7903 \$7812 VSS INVR02
* cell instance $54733 m0 *1 1818.7,3794.1
X$54733 \$18 \$7814 \$7711 VSS INVR06
* cell instance $54739 m0 *1 1889.57,3794.1
X$54739 \$18 \$7711 \$7815 VSS INVR02
* cell instance $54748 m0 *1 1954.08,3794.1
X$54748 \$18 \$7816 \$7909 VSS INVR03
* cell instance $54754 m0 *1 1997.4,3794.1
X$54754 \$18 \$7817 \$7910 VSS INVR03
* cell instance $54760 r180 *1 2071.19,3794.1
X$54760 \$7745 \$7546 \$18 \$7822 VSS OR2101
* cell instance $54762 m0 *1 2071.19,3794.1
X$54762 \$7711 \$18 \$6055 VSS INVR05
* cell instance $54763 m0 *1 2096.39,3794.1
X$54763 \$18 \$7711 \$7819 VSS INVR02
* cell instance $54764 r180 *1 2125.79,3794.1
X$54764 \$7745 \$18 \$7821 VSS INVR01
* cell instance $54765 r180 *1 2138.39,3794.1
X$54765 \$7822 \$18 \$7713 VSS INVR01
* cell instance $54768 m0 *1 2146.32,3794.1
X$54768 \$18 \$7550 \$7187 \$7714 VSS AND201
* cell instance $54772 r180 *1 2199.06,3794.1
X$54772 \$7821 \$7714 \$18 \$7913 VSS OR2101
* cell instance $54773 r180 *1 2215.87,3794.1
X$54773 \$18 \$6916 \$7713 VSS INVR02
* cell instance $54776 m0 *1 2229.08,3794.1
X$54776 \$18 \$7194 \$7556 VSS INVR03
* cell instance $54780 m0 *1 2353.64,3794.1
X$54780 \$18 \$7624 \$7193 VSS INVR06
* cell instance $54781 m0 *1 2383.64,3794.1
X$54781 \$18 \$7923 \$7924 VSS INVR03
* cell instance $54786 m0 *1 2424.16,3794.1
X$54786 \$18 \$7199 \$7828 VSS INVR03
* cell instance $54788 m0 *1 2440.96,3794.1
X$54788 \$18 \$7828 \$7970 VSS INVR03
* cell instance $54789 m0 *1 2457.77,3794.1
X$54789 \$18 \$7829 \$7970 VSS INVR06
* cell instance $54790 m0 *1 2487.17,3794.1
X$54790 \$18 \$7828 \$7197 VSS INVR03
* cell instance $54793 m0 *1 2513.38,3794.1
X$54793 \$18 \$7566 \$7829 VSS INVR06
* cell instance $54796 m0 *1 2549.07,3794.1
X$54796 \$7931 \$7930 \$7573 \$18 VSS NND201
* cell instance $54797 r180 *1 2582.67,3794.1
X$54797 \$6919 \$7933 \$7567 \$18 VSS NND201
* cell instance $54799 r180 *1 2609.25,3794.1
X$54799 \$18 \$7934 \$7933 VSS INVR03
* cell instance $54803 m0 *1 2616.61,3794.1
X$54803 \$18 \$7833 \$7936 VSS INVR03
* cell instance $54805 m0 *1 2633.41,3794.1
X$54805 \$18 \$7834 \$7833 VSS INVR02
* cell instance $54808 m0 *1 2666.65,3794.1
X$54808 \$18 \$7719 \$7569 VSS INVR06
* cell instance $54810 r180 *1 2721.09,3794.1
X$54810 \$18 \$7836 \$7938 VSS INVR03
* cell instance $54812 m0 *1 2722.28,3794.1
X$54812 \$7574 \$18 \$7566 \$7719 VSS NOR201
* cell instance $54814 r180 *1 2789.24,3794.1
X$54814 \$18 \$7839 \$7624 \$7840 VSS AND201
* cell instance $54817 r180 *1 2819.03,3794.1
X$54817 \$7840 \$18 \$7575 VSS INVR01
* cell instance $54824 m0 *1 2849.85,3794.1
X$54824 \$18 \$7575 \$7843 VSS INVR02
* cell instance $54976 m0 *1 4069.81,3794.1
X$54976 \$5711 \$18 \$7941 VSS INVR05
* cell instance $55500 m0 *1 8268.5,3794.1
X$55500 \$18 \$7577 \$7846 VSS INVR03
* cell instance $55578 m0 *1 84.42,2907.1
X$55578 \$18 \$4422 \$4519 VSS INVR06
* cell instance $55581 m0 *1 126.43,2907.1
X$55581 \$18 \$4422 \$4789 VSS INVR02
* cell instance $55583 m0 *1 237.28,2907.1
X$55583 \$4870 \$4790 \$18 \$4876 VSS OR2101
* cell instance $55587 m0 *1 264.3,2907.1
X$55587 \$4790 \$4791 \$18 \$4690 VSS OR2101
* cell instance $55588 m0 *1 286.15,2907.1
X$55588 \$18 \$4422 \$4792 VSS INVR02
* cell instance $55592 m0 *1 323.07,2907.1
X$55592 \$4794 \$18 \$4970 VSS INVR05
* cell instance $55593 m0 *1 349.11,2907.1
X$55593 \$4738 \$18 \$4422 VSS INVR01
* cell instance $55596 m0 *1 374.92,2907.1
X$55596 \$18 \$4795 \$4796 VSS INVR02
* cell instance $55600 m0 *1 403.36,2907.1
X$55600 \$4792 \$4798 \$4795 \$18 \$4589 VSS OR3101
* cell instance $55605 m0 *1 448.77,2907.1
X$55605 \$4792 \$4591 \$4795 \$18 \$4590 VSS OR3101
* cell instance $55607 m0 *1 478.18,2907.1
X$55607 \$18 \$4800 \$4664 VSS INVR02
* cell instance $55608 m0 *1 494.98,2907.1
X$55608 \$18 \$4594 \$4803 VSS INVR02
* cell instance $55611 r180 *1 539.87,2907.1
X$55611 \$18 \$3618 \$4593 VSS INVR02
* cell instance $55614 m0 *1 543.57,2907.1
X$55614 \$4884 \$4423 \$4803 \$18 VSS NND201
* cell instance $55618 m0 *1 573.57,2907.1
X$55618 \$18 \$4412 \$4532 VSS INVR04
* cell instance $55623 r180 *1 640.4,2907.1
X$55623 \$4103 \$4592 \$18 \$4807 VSS OR2101
* cell instance $55626 r180 *1 669.45,2907.1
X$55626 \$4596 \$4810 \$4326 \$18 VSS NND201
* cell instance $55629 r180 *1 696.08,2907.1
X$55629 \$18 \$4808 \$4807 VSS INVR02
* cell instance $55637 m0 *1 746.65,2907.1
X$55637 \$18 \$4598 \$4808 VSS INVR03
* cell instance $55646 r180 *1 861.26,2907.1
X$55646 \$4601 \$4602 \$4603 \$4443 \$4810 \$18 VSS AND401
* cell instance $55649 r180 *1 882.81,2907.1
X$55649 \$18 \$4949 \$3880 VSS INVR02
* cell instance $55651 r180 *1 902.77,2907.1
X$55651 \$18 \$4112 \$4949 VSS INVR02
* cell instance $55654 m0 *1 911.47,2907.1
X$55654 \$18 \$3634 \$4697 VSS INVR06
* cell instance $55655 r180 *1 953.47,2907.1
X$55655 \$4604 \$18 \$4440 VSS INVR01
* cell instance $55659 m0 *1 1168.51,2907.1
X$55659 \$18 \$4611 \$4817 VSS INVR03
* cell instance $55660 m0 *1 1185.31,2907.1
X$55660 \$18 \$4818 \$4817 VSS INVR06
* cell instance $55674 r180 *1 1411.21,2907.1
X$55674 \$18 \$4820 \$4898 VSS INVR03
* cell instance $55690 m0 *1 1532.13,2907.1
X$55690 \$5248 \$4983 \$5142 \$18 VSS NND201
* cell instance $55699 m0 *1 1603.24,2907.1
X$55699 \$18 \$4621 \$4900 VSS INVR03
* cell instance $55701 m0 *1 1725.19,2907.1
X$55701 \$18 \$4822 \$4821 \$4902 VSS AND201
* cell instance $55702 r180 *1 1767.19,2907.1
X$55702 \$18 \$4907 \$4905 VSS INVR03
* cell instance $55703 m0 *1 1767.19,2907.1
X$55703 \$18 \$4823 \$4627 VSS INVR02
* cell instance $55708 m0 *1 1813.46,2907.1
X$55708 \$18 \$4908 \$3654 VSS INVR02
* cell instance $55710 m0 *1 1830.26,2907.1
X$55710 \$18 \$3640 \$4826 VSS INVR02
* cell instance $55711 m0 *1 1847.06,2907.1
X$55711 \$18 \$4215 \$4360 VSS INVR03
* cell instance $55712 m0 *1 1863.86,2907.1
X$55712 \$18 \$4625 \$4783 VSS INVR02
* cell instance $55714 r180 *1 1916.05,2907.1
X$55714 \$18 \$4619 \$4911 VSS INVR06
* cell instance $55717 m0 *1 1918.94,2907.1
X$55717 \$18 \$4783 \$4630 VSS INVR03
* cell instance $55718 m0 *1 1935.74,2907.1
X$55718 \$18 \$3575 \$4641 VSS INVR03
* cell instance $55720 m0 *1 1958.13,2907.1
X$55720 \$18 \$5074 \$4753 VSS INVR02
* cell instance $55725 r180 *1 2028.11,2907.1
X$55725 \$4753 \$4836 \$4626 \$18 VSS XNR201
* cell instance $55727 m0 *1 2028.12,2907.1
X$55727 \$4837 \$4753 \$4838 \$18 VSS NND201
* cell instance $55729 m0 *1 2054.13,2907.1
X$55729 \$18 \$4631 \$4915 VSS INVR03
* cell instance $55733 m0 *1 2084.14,2907.1
X$55733 \$18 \$4838 \$4840 VSS INVR03
* cell instance $55737 r180 *1 2133.75,2907.1
X$55737 \$4844 \$4836 \$18 \$4840 VSS OR2101
* cell instance $55741 r180 *1 2179.47,2907.1
X$55741 \$4841 \$4840 \$5349 \$18 VSS XNR201
* cell instance $55744 r180 *1 2197.62,2907.1
X$55744 \$4633 \$18 \$4640 VSS INVR01
* cell instance $55747 r180 *1 2222.45,2907.1
X$55747 \$4923 \$4844 \$18 \$4920 VSS OR2101
* cell instance $55751 m0 *1 2239.04,2907.1
X$55751 \$4638 \$4640 \$4371 \$18 VSS NND201
* cell instance $55752 m0 *1 2255.84,2907.1
X$55752 \$18 \$4639 \$4378 VSS INVR03
* cell instance $55753 m0 *1 2272.65,2907.1
X$55753 \$18 \$4849 \$4848 VSS INVR02
* cell instance $55754 m0 *1 2289.45,2907.1
X$55754 \$18 \$3429 \$4849 VSS INVR02
* cell instance $55756 r180 *1 2328.35,2907.1
X$55756 \$18 \$4647 \$4923 VSS INVR03
* cell instance $55761 r180 *1 2361.45,2907.1
X$55761 \$18 \$4644 \$4646 \$4383 VSS AND201
* cell instance $55765 m0 *1 2376.86,2907.1
X$55765 \$18 \$4852 \$4646 VSS INVR03
* cell instance $55770 r180 *1 2439.76,2907.1
X$55770 \$4853 \$4648 \$18 \$4168 VSS OR2101
* cell instance $55772 r180 *1 2456.57,2907.1
X$55772 \$18 \$4854 \$4920 VSS INVR03
* cell instance $55774 m0 *1 2461.43,2907.1
X$55774 \$4168 \$4168 \$18 \$2992 VSS OR2101
* cell instance $55778 m0 *1 2497.62,2907.1
X$55778 \$18 \$4168 \$4857 VSS INVR02
* cell instance $56250 m0 *1 6257.66,2907.1
X$56250 \$18 \$4859 \$2670 VSS INVR06
* cell instance $56576 m0 *1 55.8,3084.5
X$56576 \$4876 \$18 \$4685 VSS INVR05
* cell instance $56578 m0 *1 86.58,3084.5
X$56578 \$5313 \$4789 \$5385 \$18 VSS XNR201
* cell instance $56580 m0 *1 126.3,3084.5
X$56580 \$18 \$5387 \$5386 \$5385 VSS AND201
* cell instance $56585 m0 *1 166.52,3084.5
X$56585 \$18 \$5110 \$5389 VSS INVR02
* cell instance $56587 r180 *1 212.72,3084.5
X$56587 \$5313 \$5517 \$5639 \$18 \$4796 VSS OR3101
* cell instance $56588 m0 *1 212.72,3084.5
X$56588 \$18 \$5119 \$5109 VSS INVR02
* cell instance $56589 m0 *1 229.52,3084.5
X$56589 \$18 \$5584 \$5315 VSS INVR02
* cell instance $56591 m0 *1 355.52,3084.5
X$56591 \$18 \$5393 \$5394 VSS INVR03
* cell instance $56592 m0 *1 372.32,3084.5
X$56592 \$18 \$5395 \$5319 VSS INVR03
* cell instance $56593 m0 *1 389.12,3084.5
X$56593 \$5127 \$18 \$5315 \$5397 \$5319 VSS NND301
* cell instance $56595 m0 *1 513.93,3084.5
X$56595 \$5401 \$18 \$5319 VSS INVR01
* cell instance $56596 m0 *1 526.53,3084.5
X$56596 \$5401 \$5589 \$18 \$5652 VSS OR2101
* cell instance $56597 m0 *1 547.53,3084.5
X$56597 \$18 \$5402 \$5403 VSS INVR02
* cell instance $56598 m0 *1 564.33,3084.5
X$56598 \$4530 \$5129 \$5127 \$18 \$5122 VSS OR3101
* cell instance $56600 r180 *1 618.55,3084.5
X$56600 \$18 \$5125 \$5323 VSS INVR02
* cell instance $56603 m0 *1 631.75,3084.5
X$56603 \$18 \$5405 \$4795 VSS INVR03
* cell instance $56607 r180 *1 678.55,3084.5
X$56607 \$18 \$5323 \$5406 VSS INVR02
* cell instance $56611 m0 *1 695.27,3084.5
X$56611 \$18 \$5408 \$5407 VSS INVR06
* cell instance $56612 m0 *1 725.27,3084.5
X$56612 \$18 \$5409 \$5316 VSS INVR02
* cell instance $56620 m0 *1 789.38,3084.5
X$56620 \$18 \$5327 \$5411 VSS INVR03
* cell instance $56622 m0 *1 806.18,3084.5
X$56622 \$18 \$5412 \$5327 VSS INVR02
* cell instance $56632 m0 *1 886.37,3084.5
X$56632 \$18 \$5328 \$5131 \$5413 VSS AND201
* cell instance $56634 r180 *1 929.78,3084.5
X$56634 \$5414 \$4441 \$5411 \$18 VSS NND201
* cell instance $56637 r180 *1 959.62,3084.5
X$56637 \$18 \$5042 \$3880 \$5331 VSS AND201
* cell instance $56640 r180 *1 988.24,3084.5
X$56640 \$5331 \$18 \$5415 VSS INVR01
* cell instance $56643 m0 *1 1005.93,3084.5
X$56643 \$5328 \$5132 \$18 \$5136 VSS OR2101
* cell instance $56653 m0 *1 1088.77,3084.5
X$56653 \$18 \$5332 \$4895 VSS INVR03
* cell instance $56656 m0 *1 1109.77,3084.5
X$56656 \$5418 \$5501 \$18 \$5134 VSS OR2101
* cell instance $56657 m0 *1 1130.77,3084.5
X$56657 \$18 \$5501 \$5332 VSS INVR02
* cell instance $56661 m0 *1 1159.2,3084.5
X$56661 \$18 \$5420 \$5138 VSS INVR06
* cell instance $56662 r180 *1 1205.54,3084.5
X$56662 \$18 \$5421 \$5046 VSS INVR03
* cell instance $56666 m0 *1 1216.89,3084.5
X$56666 \$5424 \$18 \$5415 \$5141 VSS NOR201
* cell instance $56669 r180 *1 1283.39,3084.5
X$56669 \$5424 \$5048 \$18 \$5382 VSS OR2101
* cell instance $56673 r180 *1 1321.52,3084.5
X$56673 \$18 \$5382 \$5011 \$5428 VSS AND201
* cell instance $56677 r180 *1 1354.68,3084.5
X$56677 \$18 \$5429 \$5430 \$3227 VSS AND201
* cell instance $56678 r180 *1 1371.48,3084.5
X$56678 \$18 \$5505 \$5052 VSS INVR02
* cell instance $56679 r180 *1 1405.08,3084.5
X$56679 \$5505 \$18 \$4983 \$5142 VSS NOR201
* cell instance $56680 r180 *1 1421.88,3084.5
X$56680 \$5335 \$5433 \$4898 \$18 VSS NND201
* cell instance $56683 m0 *1 1432.8,3084.5
X$56683 \$18 \$3066 \$4820 VSS INVR02
* cell instance $56685 r180 *1 1477.79,3084.5
X$56685 \$18 \$5436 \$5430 \$5438 VSS AND201
* cell instance $56686 m0 *1 1477.79,3084.5
X$56686 \$18 \$5439 \$5430 VSS INVR03
* cell instance $56687 m0 *1 1494.59,3084.5
X$56687 \$5149 \$5248 \$5438 \$18 VSS NND201
* cell instance $56688 m0 *1 1511.39,3084.5
X$56688 \$18 \$5338 \$5442 VSS INVR03
* cell instance $56689 m0 *1 1528.19,3084.5
X$56689 \$18 \$5443 \$5247 VSS INVR03
* cell instance $56693 r180 *1 1628.73,3084.5
X$56693 \$5449 \$5444 \$4983 \$18 VSS NND201
* cell instance $56695 r180 *1 1649.73,3084.5
X$56695 \$5446 \$5444 \$18 \$5445 VSS OR2101
* cell instance $56696 r180 *1 1667.13,3084.5
X$56696 \$18 \$4900 \$5447 VSS INVR03
* cell instance $56699 r180 *1 1705.53,3084.5
X$56699 \$18 \$5153 \$5449 \$5255 VSS AND201
* cell instance $56704 r180 *1 1737.37,3084.5
X$56704 \$18 \$5061 \$5446 VSS INVR03
* cell instance $56706 m0 *1 1737.37,3084.5
X$56706 \$18 \$5452 \$5009 \$4821 VSS AND201
* cell instance $56708 m0 *1 1766.68,3084.5
X$56708 \$5452 \$5157 \$18 \$5068 VSS OR2101
* cell instance $56715 m0 *1 1835.77,3084.5
X$56715 \$18 \$4826 \$5161 VSS INVR02
* cell instance $56717 m0 *1 1856.53,3084.5
X$56717 \$18 \$5454 \$5455 VSS INVR03
* cell instance $56721 m0 *1 1889.8,3084.5
X$56721 \$18 \$3654 \$4821 VSS INVR03
* cell instance $56723 m0 *1 1915.63,3084.5
X$56723 \$18 \$3655 \$5459 VSS INVR02
* cell instance $56728 r180 *1 2140.58,3084.5
X$56728 \$18 \$5462 \$2835 \$5349 VSS AND201
* cell instance $56729 m0 *1 2140.58,3084.5
X$56729 \$18 \$5463 \$5262 VSS INVR03
* cell instance $56732 r180 *1 2200.64,3084.5
X$56732 \$18 \$5468 \$5467 VSS INVR02
* cell instance $56735 m0 *1 2213.55,3084.5
X$56735 \$18 \$5466 \$5174 VSS INVR03
* cell instance $56738 r180 *1 2260.25,3084.5
X$56738 \$18 \$5467 \$3743 VSS INVR02
* cell instance $56742 r180 *1 2290.64,3084.5
X$56742 \$18 \$2992 \$4854 VSS INVR02
* cell instance $56744 m0 *1 2292.62,3084.5
X$56744 \$18 \$5459 \$3665 VSS INVR03
* cell instance $56746 m0 *1 2309.68,3084.5
X$56746 \$18 \$5088 \$5473 VSS INVR03
* cell instance $56747 m0 *1 2327.75,3084.5
X$56747 \$5179 \$18 \$4755 VSS INVR05
* cell instance $56749 m0 *1 2352.95,3084.5
X$56749 \$18 \$5475 \$4161 VSS INVR02
* cell instance $56752 r180 *1 2418.68,3084.5
X$56752 \$5266 \$5090 \$5477 \$18 VSS XNR201
* cell instance $56754 m0 *1 2418.69,3084.5
X$56754 \$18 \$5478 \$5479 VSS INVR02
* cell instance $56755 m0 *1 2435.49,3084.5
X$56755 \$18 \$4650 \$5180 VSS INVR02
* cell instance $56759 r180 *1 2508.86,3084.5
X$56759 \$5184 \$5179 \$4995 \$18 VSS XNR201
* cell instance $56761 m0 *1 2512.96,3084.5
X$56761 \$5183 \$5266 \$18 \$5184 VSS OR2101
* cell instance $56912 r180 *1 3758.8,3084.5
X$56912 \$18 \$5481 \$2511 VSS INVR06
* cell instance $56995 m0 *1 4402.01,3084.5
X$56995 \$18 \$2418 \$5483 VSS INVR03
* cell instance $56997 m0 *1 4419.41,3084.5
X$56997 \$18 \$5356 \$5483 VSS INVR06
* cell instance $56998 m0 *1 4449.41,3084.5
X$56998 \$18 \$5484 \$5356 VSS INVR06
* cell instance $57550 m0 *1 136.47,3261.9
X$57550 \$18 \$5902 \$6106 VSS INVR03
* cell instance $57554 m0 *1 167.32,3261.9
X$57554 \$18 \$5639 \$5983 VSS INVR02
* cell instance $57555 m0 *1 184.12,3261.9
X$57555 \$5984 \$5644 \$18 \$4876 VSS OR2101
* cell instance $57556 m0 *1 205.13,3261.9
X$57556 \$18 \$5985 \$5902 VSS INVR02
* cell instance $57558 r180 *1 268.74,3261.9
X$57558 \$6312 \$5986 \$5903 \$18 VSS NND201
* cell instance $57559 m0 *1 268.74,3261.9
X$57559 \$18 \$5841 \$5903 VSS INVR02
* cell instance $57562 m0 *1 298.74,3261.9
X$57562 \$18 \$5228 \$5313 VSS INVR03
* cell instance $57567 m0 *1 330.51,3261.9
X$57567 \$18 \$5238 \$5652 VSS INVR02
* cell instance $57571 m0 *1 360.51,3261.9
X$57571 \$18 \$3856 \$5987 VSS INVR06
* cell instance $57576 r180 *1 521.19,3261.9
X$57576 \$18 \$5910 \$3856 \$5844 VSS AND201
* cell instance $57577 m0 *1 521.2,3261.9
X$57577 \$18 \$5910 \$6077 VSS INVR02
* cell instance $57578 m0 *1 538,3261.9
X$57578 \$18 \$6077 \$5909 VSS INVR03
* cell instance $57579 m0 *1 554.8,3261.9
X$57579 \$18 \$5992 \$5993 VSS INVR02
* cell instance $57581 m0 *1 657.15,3261.9
X$57581 \$18 \$5996 \$5659 VSS INVR03
* cell instance $57582 m0 *1 673.95,3261.9
X$57582 \$18 \$5408 \$5998 VSS INVR03
* cell instance $57583 m0 *1 690.75,3261.9
X$57583 \$18 \$5408 \$5409 VSS INVR02
* cell instance $57592 m0 *1 766.05,3261.9
X$57592 \$18 \$5846 \$5999 VSS INVR03
* cell instance $57593 m0 *1 883.65,3261.9
X$57593 \$18 \$6002 \$5846 VSS INVR02
* cell instance $57596 m0 *1 913.65,3261.9
X$57596 \$18 \$5131 \$6003 VSS INVR02
* cell instance $57599 m0 *1 935.83,3261.9
X$57599 \$18 \$5135 \$6004 VSS INVR02
* cell instance $57605 r180 *1 1002.65,3261.9
X$57605 \$6006 \$5744 \$18 \$5919 VSS OR2101
* cell instance $57609 m0 *1 1015.24,3261.9
X$57609 \$18 \$6007 \$6008 VSS INVR03
* cell instance $57610 m0 *1 1032.04,3261.9
X$57610 \$18 \$6008 \$3227 VSS INVR03
* cell instance $57611 r180 *1 1074.04,3261.9
X$57611 \$18 \$5919 \$6116 \$5011 VSS AND201
* cell instance $57614 r180 *1 1112.44,3261.9
X$57614 \$5524 \$18 \$5747 VSS INVR05
* cell instance $57616 m0 *1 1112.44,3261.9
X$57616 \$18 \$5063 \$5044 VSS INVR02
* cell instance $57618 r180 *1 1171.63,3261.9
X$57618 \$5673 \$18 \$5420 \$6011 VSS NOR201
* cell instance $57620 r180 *1 1191.41,3261.9
X$57620 \$5923 \$4818 \$6013 \$18 VSS NND201
* cell instance $57621 m0 *1 1191.41,3261.9
X$57621 \$18 \$5923 \$6170 VSS INVR03
* cell instance $57622 m0 *1 1208.21,3261.9
X$57622 \$5678 \$5420 \$6011 \$18 VSS NND201
* cell instance $57623 r180 *1 1242.34,3261.9
X$57623 \$6015 \$5681 \$5141 \$18 VSS NND201
* cell instance $57624 r180 *1 1259.14,3261.9
X$57624 \$18 \$5754 \$5750 VSS INVR02
* cell instance $57631 r180 *1 1319.15,3261.9
X$57631 \$5436 \$6017 \$18 \$5681 VSS OR2101
* cell instance $57636 m0 *1 1447.97,3261.9
X$57636 \$18 \$5686 \$5851 VSS INVR02
* cell instance $57637 m0 *1 1464.77,3261.9
X$57637 \$18 \$6023 \$5439 VSS INVR02
* cell instance $57639 r180 *1 1517.2,3261.9
X$57639 \$5445 \$18 \$5856 \$5764 VSS NOR201
* cell instance $57641 r180 *1 1657.83,3261.9
X$57641 \$6125 \$5764 \$6124 \$18 VSS XNR201
* cell instance $57642 m0 *1 1657.83,3261.9
X$57642 \$18 \$6025 \$6178 VSS INVR02
* cell instance $57643 r180 *1 1691.43,3261.9
X$57643 \$18 \$5934 \$6026 VSS INVR02
* cell instance $57645 m0 *1 1696.23,3261.9
X$57645 \$18 \$5699 \$5068 VSS INVR02
* cell instance $57646 m0 *1 1713.03,3261.9
X$57646 \$18 \$5699 \$5156 VSS INVR06
* cell instance $57648 r180 *1 1768.86,3261.9
X$57648 \$6030 \$5934 \$18 \$5699 VSS OR2101
* cell instance $57650 m0 *1 1769.46,3261.9
X$57650 \$6031 \$5934 \$5160 \$18 VSS NND201
* cell instance $57651 m0 *1 1786.26,3261.9
X$57651 \$6032 \$18 \$5857 VSS INVR01
* cell instance $57652 m0 *1 1798.86,3261.9
X$57652 \$18 \$6026 \$5856 VSS INVR02
* cell instance $57653 r180 *1 1832.46,3261.9
X$57653 \$18 \$5775 \$4987 VSS INVR03
* cell instance $57656 r180 *1 1860.49,3261.9
X$57656 \$18 \$5959 \$5863 VSS INVR02
* cell instance $57659 m0 *1 1864.8,3261.9
X$57659 \$6036 \$6037 \$18 \$6128 VSS OR2101
* cell instance $57660 m0 *1 1885.8,3261.9
X$57660 \$3825 \$18 \$6038 VSS INVR05
* cell instance $57661 m0 *1 1911,3261.9
X$57661 \$18 \$6041 \$6038 VSS INVR06
* cell instance $57662 r180 *1 1957.2,3261.9
X$57662 \$18 \$6043 \$5959 VSS INVR02
* cell instance $57663 m0 *1 1957.2,3261.9
X$57663 \$18 \$5774 \$6043 VSS INVR02
* cell instance $57664 m0 *1 1974,3261.9
X$57664 \$18 \$6045 \$6046 VSS INVR03
* cell instance $57665 m0 *1 1990.81,3261.9
X$57665 \$18 \$5864 \$6048 VSS INVR02
* cell instance $57668 m0 *1 2025.31,3261.9
X$57668 \$6050 \$6133 \$5939 \$5778 \$4915 \$18 VSS AOI401
* cell instance $57670 m0 *1 2071.51,3261.9
X$57670 \$6133 \$18 \$6052 VSS INVR01
* cell instance $57671 m0 *1 2084.11,3261.9
X$57671 \$18 \$5939 \$5779 VSS INVR02
* cell instance $57672 m0 *1 2100.91,3261.9
X$57672 \$18 \$6053 \$5705 VSS INVR06
* cell instance $57673 m0 *1 2130.31,3261.9
X$57673 \$18 \$6053 \$6054 VSS INVR02
* cell instance $57674 m0 *1 2147.11,3261.9
X$57674 \$18 \$6055 \$6054 VSS INVR06
* cell instance $57677 m0 *1 2281.89,3261.9
X$57677 \$18 \$5941 \$6057 VSS INVR02
* cell instance $57678 m0 *1 2298.7,3261.9
X$57678 \$18 \$6057 \$5864 VSS INVR02
* cell instance $57687 m0 *1 2385.09,3261.9
X$57687 \$18 \$5479 \$5786 VSS INVR03
* cell instance $57856 r180 *1 3776.15,3261.9
X$57856 \$18 \$6061 \$2839 VSS INVR06
* cell instance $57890 m0 *1 4023.8,3261.9
X$57890 \$18 \$6064 \$6063 VSS INVR06
* cell instance $57892 m0 *1 4058.39,3261.9
X$57892 \$18 \$2643 \$5710 VSS INVR03
* cell instance $58124 m0 *1 6114.47,3261.9
X$58124 \$5948 \$18 \$3278 VSS INVR05
* cell instance $58471 m0 *1 118.98,2729.7
X$58471 \$18 \$4079 \$4411 VSS INVR03
* cell instance $58474 m0 *1 147.87,2729.7
X$58474 \$18 \$4081 \$4412 VSS INVR06
* cell instance $58475 m0 *1 177.27,2729.7
X$58475 \$18 \$4082 \$4087 VSS INVR02
* cell instance $58479 m0 *1 209.21,2729.7
X$58479 \$18 \$4413 \$4309 VSS INVR02
* cell instance $58483 m0 *1 239.21,2729.7
X$58483 \$18 \$3862 \$4181 VSS INVR03
* cell instance $58487 r180 *1 285.84,2729.7
X$58487 \$18 \$4318 \$4418 VSS INVR02
* cell instance $58489 r180 *1 302.64,2729.7
X$58489 \$4421 \$4318 \$4423 \$18 VSS NND201
* cell instance $58490 m0 *1 302.95,2729.7
X$58490 \$18 \$4422 \$4310 VSS INVR02
* cell instance $58494 m0 *1 334.12,2729.7
X$58494 \$18 \$923 \$4260 VSS INVR02
* cell instance $58496 m0 *1 356.63,2729.7
X$58496 \$4260 \$4423 \$4232 \$18 VSS XNR201
* cell instance $58499 r180 *1 428.87,2729.7
X$58499 \$18 \$4292 \$3215 \$3613 VSS AND201
* cell instance $58501 m0 *1 428.87,2729.7
X$58501 \$18 \$4292 \$4091 VSS INVR02
* cell instance $58502 m0 *1 446.27,2729.7
X$58502 \$4432 \$18 \$3215 VSS INVR01
* cell instance $58503 r180 *1 475.67,2729.7
X$58503 \$18 \$3614 \$4318 VSS INVR02
* cell instance $58506 m0 *1 488.87,2729.7
X$58506 \$18 \$3614 \$3614 VSS INVR02
* cell instance $58510 r180 *1 544.07,2729.7
X$58510 \$18 \$4295 \$3215 \$4232 VSS AND201
* cell instance $58515 m0 *1 557.88,2729.7
X$58515 \$3711 \$18 \$4432 \$4096 VSS NOR200
* cell instance $58518 m0 *1 591.48,2729.7
X$58518 \$4105 \$4103 \$3620 \$4263 \$4326 \$18 VSS AND401
* cell instance $58519 m0 *1 630.84,2729.7
X$58519 \$18 \$3868 \$4101 VSS INVR02
* cell instance $58521 r180 *1 660.24,2729.7
X$58521 \$4263 \$18 \$2975 VSS INVR01
* cell instance $58524 m0 *1 666.45,2729.7
X$58524 \$18 \$4102 \$4110 VSS INVR03
* cell instance $58528 m0 *1 701.74,2729.7
X$58528 \$4332 \$18 \$2975 VSS INVR01
* cell instance $58542 m0 *1 816.31,2729.7
X$58542 \$18 \$4201 \$3569 VSS INVR03
* cell instance $58546 m0 *1 849.99,2729.7
X$58546 \$18 \$4265 \$3788 VSS INVR03
* cell instance $58547 m0 *1 866.79,2729.7
X$58547 \$18 \$3629 \$4265 VSS INVR02
* cell instance $58548 m0 *1 883.6,2729.7
X$58548 \$18 \$3788 \$3882 VSS INVR03
* cell instance $58549 r180 *1 917.2,2729.7
X$58549 \$18 \$4308 \$4440 VSS INVR02
* cell instance $58551 m0 *1 920.45,2729.7
X$58551 \$18 \$4335 \$4441 VSS INVR03
* cell instance $58553 r180 *1 962.45,2729.7
X$58553 \$18 \$4336 \$3634 \$4443 VSS AND201
* cell instance $58559 r180 *1 1010.14,2729.7
X$58559 \$18 \$4116 \$4308 VSS INVR02
* cell instance $58562 m0 *1 1023.21,2729.7
X$58562 \$18 \$3724 \$4445 VSS INVR02
* cell instance $58567 m0 *1 1054.2,2729.7
X$58567 \$4030 \$4341 \$18 \$4445 VSS OR2101
* cell instance $58570 m0 *1 1086.62,2729.7
X$58570 \$4341 \$4342 \$4343 \$18 VSS XNR201
* cell instance $58581 m0 *1 1191.14,2729.7
X$58581 \$18 \$4119 \$3724 VSS INVR03
* cell instance $58597 m0 *1 1402.34,2729.7
X$58597 \$18 \$4346 \$4335 VSS INVR03
* cell instance $58603 m0 *1 1454.26,2729.7
X$58603 \$18 \$4122 \$4450 VSS INVR03
* cell instance $58606 r180 *1 1500.46,2729.7
X$58606 \$18 \$4121 \$2835 \$4123 VSS AND201
* cell instance $58607 m0 *1 1500.47,2729.7
X$58607 \$18 \$4350 \$4349 VSS INVR02
* cell instance $58608 m0 *1 1517.27,2729.7
X$58608 \$18 \$4454 \$4350 VSS INVR02
* cell instance $58611 m0 *1 1540.23,2729.7
X$58611 \$18 \$4351 \$4303 VSS INVR03
* cell instance $58613 m0 *1 1562.68,2729.7
X$58613 \$18 \$4303 \$4124 VSS INVR03
* cell instance $58623 m0 *1 1634.33,2729.7
X$58623 \$18 \$4303 \$4132 VSS INVR03
* cell instance $58627 r180 *1 1687.99,2729.7
X$58627 \$18 \$4132 \$3820 VSS INVR03
* cell instance $58630 m0 *1 1701.2,2729.7
X$58630 \$18 \$4302 \$3519 VSS INVR03
* cell instance $58635 m0 *1 1733.6,2729.7
X$58635 \$18 \$4130 \$4134 VSS INVR02
* cell instance $58638 m0 *1 1753.47,2729.7
X$58638 \$18 \$4554 \$4302 VSS INVR02
* cell instance $58642 r180 *1 1805.62,2729.7
X$58642 \$18 \$4212 \$3903 \$2836 VSS AND201
* cell instance $58645 m0 *1 1822.32,2729.7
X$58645 \$18 \$3297 \$4137 VSS INVR06
* cell instance $58646 r180 *1 1889.53,2729.7
X$58646 \$4038 \$4360 \$4139 \$18 VSS XNR201
* cell instance $58649 m0 *1 1899.74,2729.7
X$58649 \$4360 \$4362 \$18 \$4135 VSS OR2101
* cell instance $58652 m0 *1 1934.55,2729.7
X$58652 \$4363 \$4362 \$4460 \$18 VSS NND201
* cell instance $58656 m0 *1 1963.38,2729.7
X$58656 \$4274 \$4135 \$4460 \$18 VSS NND201
* cell instance $58662 m0 *1 2011.36,2729.7
X$58662 \$18 \$4146 \$4216 \$4126 VSS AND201
* cell instance $58665 r180 *1 2058.16,2729.7
X$58665 \$18 \$4463 \$4460 VSS INVR02
* cell instance $58666 r180 *1 2112.76,2729.7
X$58666 \$4155 \$4370 \$4274 \$4632 \$4275 \$4360 \$4368 \$18 VSS NOR601
* cell instance $58669 r180 *1 2170.38,2729.7
X$58669 \$3917 \$4469 \$4371 \$4463 \$3248 \$18 VSS NND401
* cell instance $58671 r180 *1 2187.19,2729.7
X$58671 \$4461 \$4472 \$4469 \$18 VSS NND201
* cell instance $58676 m0 *1 2210.15,2729.7
X$58676 \$4157 \$4374 \$18 \$3247 VSS OR2101
* cell instance $58679 r180 *1 2259.66,2729.7
X$58679 \$18 \$4278 \$4371 VSS INVR03
* cell instance $58683 m0 *1 2348,2729.7
X$58683 \$18 \$4376 \$4505 VSS INVR02
* cell instance $58684 m0 *1 2364.8,2729.7
X$58684 \$18 \$4505 \$4279 VSS INVR03
* cell instance $58687 r180 *1 2425.92,2729.7
X$58687 \$4379 \$4378 \$4377 \$18 VSS XNR201
* cell instance $58689 r180 *1 2450.62,2729.7
X$58689 \$4386 \$4379 \$18 \$4380 VSS OR2101
* cell instance $58691 m0 *1 2450.62,2729.7
X$58691 \$18 \$3930 \$4380 VSS INVR02
* cell instance $58694 m0 *1 2474.46,2729.7
X$58694 \$18 \$4378 \$4382 VSS INVR02
* cell instance $58696 r180 *1 2529.07,2729.7
X$58696 \$4385 \$4384 \$4383 \$18 VSS XNR201
* cell instance $58700 r180 *1 2569.5,2729.7
X$58700 \$4483 \$4386 \$18 \$4168 VSS OR2101
* cell instance $58947 r180 *1 4547.55,2729.7
X$58947 \$18 \$3942 \$3988 VSS INVR03
* cell instance $58977 m0 *1 4759.51,2729.7
X$58977 \$18 \$3187 \$4221 VSS INVR02
* cell instance $59493 m0 *1 113.83,2552.3
X$59493 \$3810 \$3961 \$3811 \$18 VSS XNR201
* cell instance $59494 m0 *1 151.63,2552.3
X$59494 \$18 \$3857 \$3856 \$3811 VSS AND201
* cell instance $59500 m0 *1 207.44,2552.3
X$59500 \$18 \$3859 \$3718 VSS INVR06
* cell instance $59503 m0 *1 247.22,2552.3
X$59503 \$18 \$3860 \$3706 VSS INVR03
* cell instance $59504 r180 *1 282.44,2552.3
X$59504 \$18 \$3210 \$3862 VSS INVR03
* cell instance $59508 m0 *1 295.69,2552.3
X$59508 \$18 \$3950 \$3856 \$3863 VSS AND201
* cell instance $59510 m0 *1 320.89,2552.3
X$59510 \$18 \$3950 \$3865 VSS INVR02
* cell instance $59513 m0 *1 516.53,2552.3
X$59513 \$18 \$3856 \$3951 VSS INVR03
* cell instance $59515 m0 *1 535.43,2552.3
X$59515 \$18 \$3215 \$3951 VSS INVR06
* cell instance $59518 m0 *1 575.95,2552.3
X$59518 \$18 \$3614 \$3616 VSS INVR04
* cell instance $59536 m0 *1 782.03,2552.3
X$59536 \$18 \$3626 \$3401 VSS INVR02
* cell instance $59543 m0 *1 847.33,2552.3
X$59543 \$18 \$3874 \$3631 VSS INVR03
* cell instance $59544 m0 *1 964.93,2552.3
X$59544 \$18 \$925 \$3879 VSS INVR06
* cell instance $59545 m0 *1 994.33,2552.3
X$59545 \$18 \$3879 \$3880 VSS INVR06
* cell instance $59548 m0 *1 1027.7,2552.3
X$59548 \$3883 \$18 \$3635 \$3882 VSS NOR201
* cell instance $59551 m0 *1 1071.59,2552.3
X$59551 \$18 \$3883 \$4030 VSS INVR02
* cell instance $59552 m0 *1 1088.39,2552.3
X$59552 \$18 \$3956 \$3407 \$3885 VSS AND201
* cell instance $59553 m0 *1 1113.59,2552.3
X$59553 \$18 \$3956 \$3636 VSS INVR02
* cell instance $59586 m0 *1 1377.89,2552.3
X$59586 \$18 \$4120 \$3886 VSS INVR02
* cell instance $59588 m0 *1 1394.69,2552.3
X$59588 \$18 \$3887 \$3638 VSS INVR02
* cell instance $59591 m0 *1 1424.67,2552.3
X$59591 \$18 \$3639 \$3728 VSS INVR03
* cell instance $59593 m0 *1 1441.49,2552.3
X$59593 \$18 \$3889 \$3641 VSS INVR03
* cell instance $59594 m0 *1 1459.28,2552.3
X$59594 \$18 \$3638 \$3890 VSS INVR02
* cell instance $59595 m0 *1 1476.09,2552.3
X$59595 \$18 \$3891 \$3969 VSS INVR06
* cell instance $59597 m0 *1 1508.66,2552.3
X$59597 \$18 \$3728 \$3893 VSS INVR03
* cell instance $59602 r180 *1 1577.2,2552.3
X$59602 \$3894 \$18 \$3893 \$3820 VSS NOR201
* cell instance $59605 m0 *1 1589.47,2552.3
X$59605 \$3727 \$18 \$3820 VSS INVR01
* cell instance $59608 m0 *1 1615.06,2552.3
X$59608 \$18 \$3890 \$3896 VSS INVR02
* cell instance $59611 m0 *1 1648.06,2552.3
X$59611 \$18 \$3234 \$3897 VSS INVR02
* cell instance $59613 r180 *1 1692.42,2552.3
X$59613 \$18 \$3898 \$3896 \$3897 VSS AND201
* cell instance $59614 m0 *1 1692.42,2552.3
X$59614 \$18 \$3730 \$3235 VSS INVR02
* cell instance $59617 m0 *1 1722.42,2552.3
X$59617 \$18 \$3902 \$3903 VSS INVR03
* cell instance $59623 m0 *1 1801.81,2552.3
X$59623 \$18 \$3902 \$3420 VSS INVR02
* cell instance $59626 r180 *1 1841.8,2552.3
X$59626 \$18 \$3240 \$3906 VSS INVR02
* cell instance $59627 m0 *1 1841.81,2552.3
X$59627 \$18 \$3903 \$3653 VSS INVR03
* cell instance $59632 m0 *1 1886.33,2552.3
X$59632 \$3906 \$4039 \$2836 \$4040 \$4216 \$18 VSS AND401
* cell instance $59634 m0 *1 1924.14,2552.3
X$59634 \$18 \$3735 \$4038 VSS INVR02
* cell instance $59636 m0 *1 2046.85,2552.3
X$59636 \$18 \$3909 \$3910 VSS INVR02
* cell instance $59640 r180 *1 2115.11,2552.3
X$59640 \$3826 \$3248 \$3911 \$18 VSS XNR201
* cell instance $59642 m0 *1 2115.11,2552.3
X$59642 \$18 \$3656 \$3912 VSS INVR03
* cell instance $59647 r180 *1 2182.63,2552.3
X$59647 \$18 \$3916 \$3826 VSS INVR03
* cell instance $59653 r180 *1 2225.45,2552.3
X$59653 \$18 \$3918 \$3917 VSS INVR02
* cell instance $59656 r180 *1 2273.88,2552.3
X$59656 \$3806 \$3659 \$3662 \$18 VSS XNR201
* cell instance $59660 r180 *1 2310.67,2552.3
X$59660 \$3434 \$3806 \$18 \$3920 VSS OR2101
* cell instance $59665 r180 *1 2338.41,2552.3
X$59665 \$3920 \$18 \$3958 VSS INVR01
* cell instance $59668 r180 *1 2353.88,2552.3
X$59668 \$3958 \$18 \$2992 VSS INVR01
* cell instance $59669 m0 *1 2353.88,2552.3
X$59669 \$18 \$3436 \$3957 VSS INVR02
* cell instance $59670 m0 *1 2370.68,2552.3
X$59670 \$18 \$3957 \$3924 VSS INVR02
* cell instance $59673 m0 *1 2400.68,2552.3
X$59673 \$2992 \$3747 \$18 \$3926 VSS OR2101
* cell instance $59676 m0 *1 2427.67,2552.3
X$59676 \$2992 \$3748 \$18 \$3928 VSS OR2101
* cell instance $59678 m0 *1 2448.67,2552.3
X$59678 \$18 \$2992 \$3930 VSS INVR02
* cell instance $59682 r180 *1 2493.11,2552.3
X$59682 \$3928 \$18 \$3830 VSS INVR01
* cell instance $59685 r180 *1 2514.2,2552.3
X$59685 \$3932 \$18 \$3830 VSS INVR01
* cell instance $59898 m0 *1 4207.46,2552.3
X$59898 \$18 \$3933 \$3440 VSS INVR04
* cell instance $59903 m0 *1 4344.49,2552.3
X$59903 \$18 \$3934 \$3937 VSS INVR02
* cell instance $59906 m0 *1 4364.81,2552.3
X$59906 \$18 \$3938 \$3675 VSS INVR02
* cell instance $59910 r180 *1 4515.77,2552.3
X$59910 \$3016 \$3373 \$18 \$3579 VSS OR2101
* cell instance $59915 m0 *1 4542.8,2552.3
X$59915 \$2432 \$18 \$3682 VSS INVR05
* cell instance $59918 r180 *1 4611.17,2552.3
X$59918 \$3942 \$18 \$3684 \$3583 VSS NOR201
* cell instance $59922 m0 *1 4622.04,2552.3
X$59922 \$18 \$2867 \$3953 VSS INVR02
* cell instance $59923 m0 *1 4638.84,2552.3
X$59923 \$18 \$3953 \$3938 VSS INVR02
* cell instance $59928 r180 *1 4699.74,2552.3
X$59928 \$18 \$3326 \$3944 VSS INVR03
* cell instance $59962 m0 *1 5051.93,2552.3
X$59962 \$18 \$2566 \$3696 VSS INVR06
* cell instance $59963 m0 *1 5081.33,2552.3
X$59963 \$18 \$3946 \$2807 VSS INVR03
* cell instance $60052 m0 *1 5790.09,2552.3
X$60052 \$18 \$3834 \$2295 VSS INVR06
* cell instance $60438 m0 *1 3994.2,68.7
X$60438 \$18 \$36 \$77 VSS INVR06
* cell instance $60446 m0 *1 4099.22,68.7
X$60446 \$18 \$611 \$37 VSS INVR06
* cell instance $60449 r180 *1 4162.21,68.7
X$60449 \$18 \$38 \$78 VSS INVR03
* cell instance $60456 m0 *1 4225.66,68.7
X$60456 \$18 \$157 \$79 VSS INVR06
* cell instance $60457 m0 *1 4284.46,68.7
X$60457 \$18 \$160 \$79 VSS INVR03
* cell instance $60458 m0 *1 4326.46,68.7
X$60458 \$18 \$21 \$83 VSS INVR03
* cell instance $60459 m0 *1 4372.66,68.7
X$60459 \$18 \$44 \$48 VSS INVR06
* cell instance $60460 m0 *1 4402.06,68.7
X$60460 \$89 \$46 \$45 \$47 \$52 \$18 VSS NOR401
* cell instance $60461 m0 *1 4448.32,68.7
X$60461 \$18 \$48 \$162 VSS INVR04
* cell instance $60463 m0 *1 4478.32,68.7
X$60463 \$18 \$42 \$115 VSS INVR02
* cell instance $60465 m0 *1 4495.12,68.7
X$60465 \$18 \$50 \$49 \$166 VSS AND201
* cell instance $60467 r180 *1 4556.85,68.7
X$60467 \$51 \$18 \$52 \$120 VSS NOR201
* cell instance $60468 r180 *1 4573.65,68.7
X$60468 \$18 \$51 \$53 VSS INVR02
* cell instance $60478 m0 *1 4658.57,68.7
X$60478 \$54 \$107 \$18 \$120 VSS OR2101
* cell instance $60480 m0 *1 4679.57,68.7
X$60480 \$18 \$107 \$25 VSS INVR02
* cell instance $60481 m0 *1 4696.37,68.7
X$60481 \$88 \$55 \$18 \$89 VSS OR2101
* cell instance $60482 m0 *1 4717.37,68.7
X$60482 \$18 \$25 \$89 VSS INVR02
* cell instance $60483 m0 *1 4734.17,68.7
X$60483 \$57 \$18 \$56 \$45 VSS NOR201
* cell instance $60484 m0 *1 4767.77,68.7
X$60484 \$18 \$127 \$45 VSS INVR02
* cell instance $60485 m0 *1 4784.57,68.7
X$60485 \$18 \$47 \$168 VSS INVR02
* cell instance $60487 r180 *1 4870.79,68.7
X$60487 \$18 \$29 \$26 VSS INVR02
* cell instance $60490 m0 *1 4883.99,68.7
X$60490 \$18 \$63 \$62 \$58 VSS AND201
* cell instance $60493 r180 *1 4930.79,68.7
X$60493 \$18 \$62 \$29 VSS INVR02
* cell instance $60499 m0 *1 5002.21,68.7
X$60499 \$18 \$63 \$100 VSS INVR02
* cell instance $60503 m0 *1 5031.64,68.7
X$60503 \$31 \$18 \$64 \$101 VSS NOR201
* cell instance $60504 m0 *1 5065.24,68.7
X$60504 \$18 \$100 \$177 VSS INVR02
* cell instance $60507 m0 *1 5095.3,68.7
X$60507 \$225 \$65 \$18 \$103 VSS OR2101
* cell instance $60509 r180 *1 5145.7,68.7
X$60509 \$18 \$27 \$103 VSS INVR06
* cell instance $60980 m0 *1 3984.08,1310.5
X$60980 \$18 \$1596 \$1559 VSS INVR03
* cell instance $60989 m0 *1 4303.45,1310.5
X$60989 \$1566 \$18 \$1559 VSS INVR05
* cell instance $60990 r180 *1 4366.45,1310.5
X$60990 \$1141 \$1442 \$1441 \$18 VSS XNR201
* cell instance $60991 m0 *1 4366.45,1310.5
X$60991 \$18 \$1525 \$1599 VSS INVR02
* cell instance $60993 m0 *1 4385.99,1310.5
X$60993 \$18 \$1599 \$1443 VSS INVR03
* cell instance $60994 m0 *1 4402.8,1310.5
X$60994 \$18 \$1569 \$1570 VSS INVR02
* cell instance $61003 m0 *1 4478.14,1310.5
X$61003 \$18 \$1534 \$1571 VSS INVR06
* cell instance $61004 r180 *1 4524.34,1310.5
X$61004 \$18 \$1447 \$1573 VSS INVR02
* cell instance $61008 m0 *1 4539.31,1310.5
X$61008 \$18 \$1448 \$1297 \$1338 VSS AND201
* cell instance $61010 m0 *1 4572.92,1310.5
X$61010 \$18 \$1149 \$1576 VSS INVR02
* cell instance $61011 m0 *1 4589.72,1310.5
X$61011 \$18 \$1446 \$1577 VSS INVR02
* cell instance $61012 m0 *1 4607.43,1310.5
X$61012 \$18 \$1534 \$1578 VSS INVR02
* cell instance $61016 r180 *1 4668.71,1310.5
X$61016 \$1456 \$18 \$1450 VSS INVR05
* cell instance $61026 m0 *1 4723.37,1310.5
X$61026 \$18 \$1581 \$1582 VSS INVR02
* cell instance $61029 m0 *1 4753.38,1310.5
X$61029 \$18 \$1614 \$1746 VSS INVR02
* cell instance $61032 m0 *1 4772.71,1310.5
X$61032 \$18 \$1582 \$1505 VSS INVR02
* cell instance $61043 m0 *1 4869.76,1310.5
X$61043 \$18 \$1583 \$1584 VSS INVR02
* cell instance $61046 m0 *1 4903.08,1310.5
X$61046 \$18 \$1415 \$1394 VSS INVR03
* cell instance $61048 r180 *1 4938.89,1310.5
X$61048 \$18 \$1060 \$1455 VSS INVR02
* cell instance $61054 m0 *1 4969.22,1310.5
X$61054 \$18 \$882 \$948 VSS INVR02
* cell instance $61055 m0 *1 4986.02,1310.5
X$61055 \$18 \$1590 \$882 VSS INVR03
* cell instance $61056 m0 *1 5002.83,1310.5
X$61056 \$18 \$748 \$1587 VSS INVR06
* cell instance $61058 m0 *1 5038.09,1310.5
X$61058 \$1467 \$18 \$1470 \$1307 \$1471 VSS NND301
* cell instance $61066 r180 *1 5143.97,1310.5
X$61066 \$18 \$1589 \$1470 \$1590 VSS AND201
* cell instance $61068 m0 *1 5146.85,1310.5
X$61068 \$18 \$1474 \$1249 \$1315 VSS AND201
* cell instance $61070 m0 *1 5177.56,1310.5
X$61070 \$18 \$1590 \$1592 VSS INVR03
* cell instance $61074 m0 *1 5205.36,1310.5
X$61074 \$18 \$1592 \$1315 VSS INVR02
* cell instance $61084 m0 *1 5277.18,1310.5
X$61084 \$18 \$1422 \$1318 VSS INVR02
* cell instance $61093 m0 *1 5333.87,1310.5
X$61093 \$18 \$1318 \$1171 VSS INVR02
* cell instance $61536 m0 *1 4144.2,246.1
X$61536 \$18 \$236 \$311 VSS INVR02
* cell instance $61545 m0 *1 4221,246.1
X$61545 \$18 \$311 \$160 VSS INVR02
* cell instance $61548 r180 *1 4261.37,246.1
X$61548 \$18 \$287 \$237 VSS INVR02
* cell instance $61556 m0 *1 4317.79,246.1
X$61556 \$405 \$18 \$159 VSS INVR01
* cell instance $61560 m0 *1 4338.27,246.1
X$61560 \$18 \$287 \$316 VSS INVR02
* cell instance $61562 m0 *1 4364.68,246.1
X$61562 \$288 \$240 \$317 \$18 VSS XNR201
* cell instance $61566 m0 *1 4413.6,246.1
X$61566 \$18 \$308 \$320 VSS INVR02
* cell instance $61568 m0 *1 4430.4,246.1
X$61568 \$18 \$24 \$320 VSS INVR06
* cell instance $61569 r180 *1 4485,246.1
X$61569 \$287 \$18 \$322 VSS INVR05
* cell instance $61570 m0 *1 4485,246.1
X$61570 \$18 \$292 \$322 VSS INVR03
* cell instance $61571 m0 *1 4501.8,246.1
X$61571 \$18 \$323 \$292 VSS INVR02
* cell instance $61574 r180 *1 4564.33,246.1
X$61574 \$414 \$18 \$350 \$50 VSS NOR201
* cell instance $61577 r180 *1 4593.21,246.1
X$61577 \$18 \$350 \$208 \$369 VSS AND201
* cell instance $61580 r180 *1 4645.1,246.1
X$61580 \$18 \$325 \$208 VSS INVR02
* cell instance $61581 m0 *1 4682.9,246.1
X$61581 \$18 \$326 \$210 VSS INVR02
* cell instance $61584 m0 *1 4712.9,246.1
X$61584 \$18 \$327 \$355 VSS INVR02
* cell instance $61586 m0 *1 4729.7,246.1
X$61586 \$18 \$355 \$356 VSS INVR02
* cell instance $61587 m0 *1 4746.88,246.1
X$61587 \$18 \$356 \$127 VSS INVR02
* cell instance $61588 m0 *1 4763.69,246.1
X$61588 \$329 \$56 \$327 \$18 VSS NND201
* cell instance $61590 m0 *1 4785.88,246.1
X$61590 \$18 \$456 \$329 \$254 VSS AND201
* cell instance $61595 r180 *1 4848.29,246.1
X$61595 \$18 \$394 \$212 \$258 VSS AND201
* cell instance $61596 m0 *1 4848.29,246.1
X$61596 \$18 \$260 \$332 VSS INVR03
* cell instance $61602 m0 *1 4901.13,246.1
X$61602 \$18 \$333 \$258 VSS INVR02
* cell instance $61603 m0 *1 4919.69,246.1
X$61603 \$18 \$166 \$333 VSS INVR03
* cell instance $61606 r180 *1 4973.83,246.1
X$61606 \$336 \$18 \$221 \$64 \$258 VSS AND301
* cell instance $61613 r180 *1 5073.08,246.1
X$61613 \$337 \$18 \$338 \$376 VSS NOR201
* cell instance $61615 m0 *1 5077.67,246.1
X$61615 \$225 \$27 \$269 \$18 VSS XNR201
* cell instance $61620 m0 *1 5148.44,246.1
X$61620 \$18 \$333 \$340 VSS INVR02
* cell instance $61622 m0 *1 5167.11,246.1
X$61622 \$343 \$18 \$341 \$342 VSS NOR201
* cell instance $61628 m0 *1 5232.02,246.1
X$61628 \$18 \$345 \$269 \$340 VSS AND201
* cell instance $61631 m0 *1 5262.02,246.1
X$61631 \$18 \$342 \$226 \$340 VSS AND201
* cell instance $62084 m0 *1 4212.61,423.5
X$62084 \$18 \$517 \$516 \$515 VSS AND201
* cell instance $62088 r180 *1 4274.67,423.5
X$62088 \$18 \$572 \$518 \$444 VSS AND201
* cell instance $62094 r180 *1 4321.47,423.5
X$62094 \$18 \$416 \$444 VSS INVR02
* cell instance $62096 m0 *1 4326.27,423.5
X$62096 \$18 \$487 \$447 \$444 VSS AND201
* cell instance $62101 m0 *1 4379.23,423.5
X$62101 \$18 \$448 \$515 VSS INVR02
* cell instance $62104 r180 *1 4419.83,423.5
X$62104 \$446 \$522 \$18 \$42 VSS OR2101
* cell instance $62105 m0 *1 4419.83,423.5
X$62105 \$18 \$451 \$42 VSS INVR03
* cell instance $62106 m0 *1 4436.63,423.5
X$62106 \$18 \$447 \$201 VSS INVR03
* cell instance $62108 m0 *1 4461.96,423.5
X$62108 \$18 \$489 \$525 VSS INVR03
* cell instance $62111 m0 *1 4485.57,423.5
X$62111 \$489 \$18 \$411 \$410 VSS NOR201
* cell instance $62121 m0 *1 4582.28,423.5
X$62121 \$18 \$575 \$493 VSS INVR03
* cell instance $62125 m0 *1 4612.52,423.5
X$62125 \$18 \$420 \$418 \$369 VSS AND201
* cell instance $62127 m0 *1 4637.72,423.5
X$62127 \$18 \$493 \$325 VSS INVR03
* cell instance $62128 r180 *1 4671.32,423.5
X$62128 \$18 \$421 \$557 VSS INVR03
* cell instance $62129 m0 *1 4672.88,423.5
X$62129 \$18 \$591 \$451 VSS INVR02
* cell instance $62131 m0 *1 4689.68,423.5
X$62131 \$18 \$327 \$528 VSS INVR04
* cell instance $62133 r180 *1 4740.08,423.5
X$62133 \$416 \$18 \$529 VSS INVR05
* cell instance $62135 r180 *1 4770.08,423.5
X$62135 \$18 \$495 \$456 \$166 VSS AND201
* cell instance $62136 r180 *1 4786.88,423.5
X$62136 \$18 \$496 \$559 VSS INVR03
* cell instance $62139 m0 *1 4800.09,423.5
X$62139 \$18 \$530 \$170 VSS INVR03
* cell instance $62141 m0 *1 4816.89,423.5
X$62141 \$18 \$532 \$460 VSS INVR02
* cell instance $62143 m0 *1 4835.64,423.5
X$62143 \$426 \$18 \$533 \$394 VSS NOR201
* cell instance $62149 m0 *1 4947.61,423.5
X$62149 \$18 \$498 \$457 VSS INVR03
* cell instance $62152 r180 *1 4994.41,423.5
X$62152 \$18 \$429 \$536 VSS INVR03
* cell instance $62160 m0 *1 5043.81,423.5
X$62160 \$18 \$337 \$537 VSS INVR03
* cell instance $62162 m0 *1 5060.61,423.5
X$62162 \$18 \$498 \$448 VSS INVR03
* cell instance $62167 r180 *1 5126.93,423.5
X$62167 \$18 \$503 \$504 VSS INVR03
* cell instance $62169 m0 *1 5135.33,423.5
X$62169 \$18 \$28 \$539 VSS INVR06
* cell instance $62170 m0 *1 5164.73,423.5
X$62170 \$18 \$504 \$539 VSS INVR03
* cell instance $62173 r180 *1 5215.24,423.5
X$62173 \$18 \$541 \$503 VSS INVR03
* cell instance $62175 m0 *1 5220.64,423.5
X$62175 \$18 \$438 \$542 VSS INVR03
* cell instance $62179 r180 *1 5265.35,423.5
X$62179 \$18 \$545 \$541 VSS INVR03
* cell instance $62182 r180 *1 5285.52,423.5
X$62182 \$18 \$544 \$545 VSS INVR02
* cell instance $62641 r180 *1 4009.65,955.7
X$62641 \$18 \$933 \$1035 VSS INVR03
* cell instance $62644 m0 *1 4014.45,955.7
X$62644 \$1037 \$18 \$1036 VSS INVR05
* cell instance $62645 m0 *1 4039.66,955.7
X$62645 \$18 \$1038 \$1075 VSS INVR02
* cell instance $62648 m0 *1 4069.66,955.7
X$62648 \$18 \$974 \$928 VSS INVR03
* cell instance $62660 m0 *1 4157.04,955.7
X$62660 \$18 \$1041 \$932 VSS INVR02
* cell instance $62688 m0 *1 4484.65,955.7
X$62688 \$18 \$764 \$1044 VSS INVR06
* cell instance $62691 m0 *1 4521.06,955.7
X$62691 \$18 \$939 \$1046 VSS INVR02
* cell instance $62712 r180 *1 4725.44,955.7
X$62712 \$1047 \$18 \$1048 \$591 VSS NOR201
* cell instance $62714 m0 *1 4733.52,955.7
X$62714 \$18 \$1048 \$1049 VSS INVR03
* cell instance $62719 m0 *1 4769.32,955.7
X$62719 \$853 \$18 \$944 \$1047 VSS NOR201
* cell instance $62722 m0 *1 4819.08,955.7
X$62722 \$18 \$942 \$1051 VSS INVR02
* cell instance $62724 m0 *1 4845.46,955.7
X$62724 \$18 \$741 \$1052 VSS INVR02
* cell instance $62727 m0 *1 4865.3,955.7
X$62727 \$1052 \$1053 \$18 \$1015 VSS OR2101
* cell instance $62729 r180 *1 4899.51,955.7
X$62729 \$1015 \$18 \$1054 VSS INVR01
* cell instance $62738 m0 *1 4963.84,955.7
X$62738 \$18 \$1055 \$1056 VSS INVR02
* cell instance $62740 m0 *1 4985.4,955.7
X$62740 \$18 \$498 \$1057 VSS INVR03
* cell instance $62747 m0 *1 5042.02,955.7
X$62747 \$18 \$987 \$1059 VSS INVR03
* cell instance $62751 r180 *1 5088.82,955.7
X$62751 \$18 \$1071 \$1060 VSS INVR02
* cell instance $62754 r180 *1 5169.03,955.7
X$62754 \$1065 \$1051 \$955 \$1063 \$987 \$689 \$959 \$1061 \$1071 \$18 VSS
+ AND801
* cell instance $62757 m0 *1 5179.97,955.7
X$62757 \$18 \$1092 \$1066 VSS INVR02
* cell instance $62759 r180 *1 5231.45,955.7
X$62759 \$987 \$18 \$1021 VSS INVR05
* cell instance $62763 r180 *1 5258.67,955.7
X$62763 \$18 \$1022 \$1021 VSS INVR02
* cell instance $62765 r180 *1 5284.89,955.7
X$62765 \$18 \$1067 \$1022 VSS INVR02
* cell instance $62769 m0 *1 5301.95,955.7
X$62769 \$18 \$1068 \$962 VSS INVR03
* cell instance $62773 m0 *1 5322.06,955.7
X$62773 \$18 \$753 \$871 VSS INVR06
* cell instance $63218 m0 *1 3957.06,778.3
X$63218 \$18 \$757 \$841 VSS INVR02
* cell instance $63219 m0 *1 3973.86,778.3
X$63219 \$842 \$18 \$841 VSS INVR05
* cell instance $63231 m0 *1 4088.6,778.3
X$63231 \$18 \$843 \$844 VSS INVR03
* cell instance $63233 m0 *1 4105.4,778.3
X$63233 \$18 \$52 \$157 VSS INVR06
* cell instance $63255 m0 *1 4339.41,778.3
X$63255 \$18 \$308 \$695 VSS INVR06
* cell instance $63258 m0 *1 4382.61,778.3
X$63258 \$18 \$936 \$848 VSS INVR02
* cell instance $63261 m0 *1 4404.46,778.3
X$63261 \$18 \$849 \$851 VSS INVR03
* cell instance $63280 m0 *1 4552.94,778.3
X$63280 \$18 \$730 \$729 VSS INVR02
* cell instance $63282 m0 *1 4569.74,778.3
X$63282 \$817 \$18 \$323 VSS INVR01
* cell instance $63285 m0 *1 4596.09,778.3
X$63285 \$731 \$18 \$817 VSS INVR01
* cell instance $63294 r180 *1 4681.09,778.3
X$63294 \$591 \$18 \$740 VSS INVR05
* cell instance $63306 r180 *1 4775.61,778.3
X$63306 \$18 \$853 \$711 VSS INVR03
* cell instance $63311 m0 *1 4791.34,778.3
X$63311 \$18 \$819 \$824 VSS INVR02
* cell instance $63313 r180 *1 4842.62,778.3
X$63313 \$819 \$18 \$855 \$689 VSS NOR201
* cell instance $63317 m0 *1 4864.52,778.3
X$63317 \$856 \$857 \$18 \$721 VSS OR2101
* cell instance $63321 m0 *1 4896.13,778.3
X$63321 \$18 \$859 \$822 \$498 VSS AND201
* cell instance $63325 m0 *1 4935.61,778.3
X$63325 \$18 \$822 \$857 \$824 VSS AND201
* cell instance $63330 m0 *1 4984.4,778.3
X$63330 \$18 \$882 \$863 VSS INVR02
* cell instance $63333 m0 *1 5009.62,778.3
X$63333 \$824 \$223 \$825 \$18 VSS XNR201
* cell instance $63335 r180 *1 5079.09,778.3
X$63335 \$18 \$689 \$865 VSS INVR06
* cell instance $63336 m0 *1 5079.09,778.3
X$63336 \$790 \$18 \$791 \$859 VSS NOR201
* cell instance $63341 r180 *1 5162.98,778.3
X$63341 \$18 \$794 \$865 VSS INVR03
* cell instance $63351 r180 *1 5340.82,778.3
X$63351 \$18 \$753 \$870 VSS INVR03
* cell instance $63354 m0 *1 5344.48,778.3
X$63354 \$18 \$754 \$871 VSS INVR03
* cell instance $63798 r180 *1 3971.52,1487.9
X$63798 \$18 \$1724 \$1819 VSS INVR02
* cell instance $63799 m0 *1 3971.52,1487.9
X$63799 \$18 \$1434 \$1666 VSS INVR02
* cell instance $63804 m0 *1 4109.22,1487.9
X$63804 \$18 \$1668 \$1791 VSS INVR02
* cell instance $63807 m0 *1 4128.85,1487.9
X$63807 \$18 \$1879 \$1822 VSS INVR03
* cell instance $63810 m0 *1 4158.08,1487.9
X$63810 \$18 \$1463 \$196 VSS INVR06
* cell instance $63811 m0 *1 4187.48,1487.9
X$63811 \$18 \$1525 \$1822 VSS INVR06
* cell instance $63812 m0 *1 4216.95,1487.9
X$63812 \$18 \$1791 \$1827 VSS INVR02
* cell instance $63813 m0 *1 4233.75,1487.9
X$63813 \$18 \$935 \$1872 VSS INVR02
* cell instance $63814 m0 *1 4250.55,1487.9
X$63814 \$18 \$1872 \$1828 VSS INVR03
* cell instance $63815 r180 *1 4305.15,1487.9
X$63815 \$1948 \$1830 \$1829 \$18 VSS XNR201
* cell instance $63816 m0 *1 4305.15,1487.9
X$63816 \$18 \$1830 \$1882 VSS INVR04
* cell instance $63820 r180 *1 4362.98,1487.9
X$63820 \$18 \$1923 \$1832 \$1291 VSS AND201
* cell instance $63829 r180 *1 4434.38,1487.9
X$63829 \$18 \$1676 \$1291 VSS INVR02
* cell instance $63831 m0 *1 4439.23,1487.9
X$63831 \$1679 \$18 \$1834 VSS INVR01
* cell instance $63833 m0 *1 4607.23,1487.9
X$63833 \$1839 \$1614 \$1694 \$1297 \$1634 \$1844 \$1149 \$1456 \$18 VSS OR7101
* cell instance $63834 m0 *1 4674.43,1487.9
X$63834 \$1846 \$18 \$1845 VSS INVR05
* cell instance $63837 m0 *1 4711.83,1487.9
X$63837 \$1893 \$1697 \$18 \$1847 VSS OR2101
* cell instance $63839 m0 *1 4787.43,1487.9
X$63839 \$18 \$1799 \$1845 VSS INVR03
* cell instance $63841 m0 *1 4810.04,1487.9
X$63841 \$1702 \$1851 \$18 \$1959 VSS OR2101
* cell instance $63846 r180 *1 4862.97,1487.9
X$63846 \$18 \$1801 \$1537 VSS INVR02
* cell instance $63848 m0 *1 4862.97,1487.9
X$63848 \$18 \$1851 \$1801 VSS INVR02
* cell instance $63858 m0 *1 4953.22,1487.9
X$63858 \$18 \$1708 \$1471 \$1307 VSS AND201
* cell instance $63866 m0 *1 5022.98,1487.9
X$63866 \$1643 \$1470 \$1806 \$18 VSS XNR201
* cell instance $63870 m0 *1 5078.88,1487.9
X$63870 \$18 \$1856 \$1857 VSS INVR02
* cell instance $63871 m0 *1 5095.68,1487.9
X$63871 \$18 \$1858 \$1859 VSS INVR03
* cell instance $63876 m0 *1 5142.07,1487.9
X$63876 \$18 \$1713 \$1417 \$1806 VSS AND201
* cell instance $63882 m0 *1 5183.07,1487.9
X$63882 \$1803 \$18 \$1716 \$1711 VSS NOR201
* cell instance $63886 m0 *1 5236.62,1487.9
X$63886 \$18 \$1803 \$1645 VSS INVR03
* cell instance $63900 m0 *1 5382.16,1487.9
X$63900 \$18 \$1867 \$1476 VSS INVR03
* cell instance $63916 m0 *1 5514.6,1487.9
X$63916 \$18 \$1319 \$1869 VSS INVR03
* cell instance $64339 m0 *1 4211.66,600.9
X$64339 \$18 \$625 \$673 VSS INVR03
* cell instance $64342 m0 *1 4240.6,600.9
X$64342 \$18 \$674 \$675 VSS INVR02
* cell instance $64345 m0 *1 4269.64,600.9
X$64345 \$18 \$675 \$518 VSS INVR02
* cell instance $64349 m0 *1 4301.21,600.9
X$64349 \$18 \$518 \$695 VSS INVR03
* cell instance $64351 m0 *1 4322.57,600.9
X$64351 \$626 \$18 \$487 \$584 VSS NOR201
* cell instance $64354 m0 *1 4369.92,600.9
X$64354 \$18 \$627 \$677 VSS INVR02
* cell instance $64364 m0 *1 4441.32,600.9
X$64364 \$18 \$447 \$627 VSS INVR02
* cell instance $64365 m0 *1 4559.52,600.9
X$64365 \$630 \$18 \$447 VSS INVR01
* cell instance $64366 m0 *1 4572.12,600.9
X$64366 \$18 \$613 \$575 VSS INVR02
* cell instance $64367 m0 *1 4588.92,600.9
X$64367 \$18 \$574 \$681 VSS INVR02
* cell instance $64368 m0 *1 4605.72,600.9
X$64368 \$418 \$18 \$681 VSS INVR05
* cell instance $64378 r180 *1 4711.38,600.9
X$64378 \$18 \$592 \$653 VSS INVR02
* cell instance $64380 m0 *1 4711.38,600.9
X$64380 \$18 \$653 \$528 VSS INVR03
* cell instance $64387 r180 *1 4787.37,600.9
X$64387 \$18 \$532 \$684 VSS INVR02
* cell instance $64392 m0 *1 4853.74,600.9
X$64392 \$18 \$687 \$595 VSS INVR02
* cell instance $64403 r180 *1 4968.08,600.9
X$64403 \$18 \$30 \$689 VSS INVR06
* cell instance $64417 m0 *1 5063.09,600.9
X$64417 \$18 \$691 \$654 VSS INVR02
* cell instance $64418 m0 *1 5079.89,600.9
X$64418 \$18 \$686 \$222 VSS INVR03
* cell instance $64421 m0 *1 5104.12,600.9
X$64421 \$432 \$654 \$504 \$601 \$693 \$18 VSS AND401
* cell instance $64423 r180 *1 5158.73,600.9
X$64423 \$18 \$600 \$694 VSS INVR03
* cell instance $64435 m0 *1 5325.61,600.9
X$64435 \$18 \$600 \$608 VSS INVR06
* cell instance $64884 m90 *1 81,5608.1
X$64884 \$18025 \$17668 \$18 \$17875 VSS OR2101
* cell instance $64896 r0 *1 157,5608.1
X$64896 \$18 \$16987 \$17792 \$17788 VSS AND201
* cell instance $64898 r0 *1 183.66,5608.1
X$64898 \$16990 \$18 \$16518 \$17293 VSS NOR201
* cell instance $64902 m90 *1 257.13,5608.1
X$64902 \$18 \$17875 \$17669 \$16683 VSS AND201
* cell instance $64905 r0 *1 262.98,5608.1
X$64905 \$18 \$16987 \$18162 VSS INVR02
* cell instance $64906 r0 *1 279.78,5608.1
X$64906 \$17299 \$18032 \$17670 \$17949 \$17792 \$18 VSS NND401
* cell instance $64907 m90 *1 342.78,5608.1
X$64907 \$18 \$18167 \$17792 VSS INVR02
* cell instance $64908 m90 *1 356.58,5608.1
X$64908 \$17795 \$18 \$17678 VSS INVR01
* cell instance $64910 r0 *1 356.58,5608.1
X$64910 \$18 \$18037 \$17388 VSS INVR06
* cell instance $64911 r0 *1 385.98,5608.1
X$64911 \$18 \$18038 \$18039 VSS INVR03
* cell instance $64912 r0 *1 403.18,5608.1
X$64912 \$17949 \$16997 \$18041 \$18 VSS XNR201
* cell instance $64913 m90 *1 474.58,5608.1
X$64913 \$16991 \$18 \$16994 \$16997 VSS NOR201
* cell instance $64916 r0 *1 490.77,5608.1
X$64916 \$18 \$17953 \$16077 \$16997 VSS AND201
* cell instance $64918 r0 *1 519.91,5608.1
X$64918 \$17953 \$18234 \$18 \$18046 VSS OR2101
* cell instance $64920 r0 *1 540.91,5608.1
X$64920 \$18 \$18234 \$18038 VSS INVR02
* cell instance $64926 r0 *1 589.47,5608.1
X$64926 \$18 \$17395 \$17955 VSS INVR03
* cell instance $64930 r0 *1 719.19,5608.1
X$64930 \$18 \$17215 \$17798 VSS INVR06
* cell instance $64934 r0 *1 869.9,5608.1
X$64934 \$18 \$17306 \$18052 VSS INVR02
* cell instance $64936 r0 *1 886.7,5608.1
X$64936 \$18 \$17004 \$17960 VSS INVR03
* cell instance $64938 r0 *1 905.88,5608.1
X$64938 \$18 \$18052 \$17804 VSS INVR02
* cell instance $64942 m90 *1 1007.76,5608.1
X$64942 \$18054 \$17960 \$17808 \$18 VSS NND201
* cell instance $64944 r0 *1 1007.76,5608.1
X$64944 \$17693 \$17960 \$14601 \$18 VSS NND201
* cell instance $64947 r0 *1 1083.64,5608.1
X$64947 \$18 \$17013 \$17418 VSS INVR02
* cell instance $64948 r0 *1 1100.44,5608.1
X$64948 \$18 \$18058 \$17698 VSS INVR03
* cell instance $64954 r0 *1 1193.82,5608.1
X$64954 \$18 \$17808 \$18062 VSS INVR02
* cell instance $64955 m90 *1 1231.62,5608.1
X$64955 \$17429 \$17700 \$18 \$17017 VSS OR2101
* cell instance $64956 r0 *1 1231.62,5608.1
X$64956 \$18 \$17697 \$18068 VSS INVR02
* cell instance $64959 r0 *1 1262.22,5608.1
X$64959 \$18 \$18068 \$14601 VSS INVR02
* cell instance $64964 r0 *1 1300.62,5608.1
X$64964 \$17699 \$17705 \$18 \$17017 VSS OR2101
* cell instance $64982 r0 *1 1439.89,5608.1
X$64982 \$18 \$18072 \$17813 VSS INVR02
* cell instance $64983 r0 *1 1456.7,5608.1
X$64983 \$18 \$17817 \$18072 VSS INVR02
* cell instance $64984 m90 *1 1499.39,5608.1
X$64984 \$18 \$17824 \$17813 \$17708 VSS AND201
* cell instance $64987 r0 *1 1510.76,5608.1
X$64987 \$18 \$18018 \$18077 \$17708 VSS AND201
* cell instance $64990 m90 *1 1561.92,5608.1
X$64990 \$17968 \$18193 \$18 \$18018 VSS OR2101
* cell instance $64991 r0 *1 1561.92,5608.1
X$64991 \$18 \$18193 \$18261 VSS INVR02
* cell instance $64992 r0 *1 1578.72,5608.1
X$64992 \$18 \$18261 \$18080 VSS INVR03
* cell instance $64997 m90 *1 1643.72,5608.1
X$64997 \$18 \$17825 \$17030 \$16582 VSS AND201
* cell instance $64999 m90 *1 1668.92,5608.1
X$64999 \$18 \$18084 \$15961 \$16582 VSS AND201
* cell instance $65000 r0 *1 1668.92,5608.1
X$65000 \$18 \$18087 \$18088 VSS INVR03
* cell instance $65001 m90 *1 1711.24,5608.1
X$65001 \$18 \$17968 \$17970 \$16582 VSS AND201
* cell instance $65005 m90 *1 1750.84,5608.1
X$65005 \$18 \$18091 \$13570 \$16582 VSS AND201
* cell instance $65010 m90 *1 1808.79,5608.1
X$65010 \$15961 \$18 \$17719 VSS INVR05
* cell instance $65012 r0 *1 1813.59,5608.1
X$65012 \$18 \$16587 \$18095 VSS INVR03
* cell instance $65021 r0 *1 1892.01,5608.1
X$65021 \$18 \$17832 \$17595 VSS INVR02
* cell instance $65023 r0 *1 1908.81,5608.1
X$65023 \$18 \$17970 \$16147 VSS INVR02
* cell instance $65026 r0 *1 1932.51,5608.1
X$65026 \$18 \$18100 \$18099 VSS INVR06
* cell instance $65030 r0 *1 1980.52,5608.1
X$65030 \$18 \$18101 \$16144 VSS INVR02
* cell instance $65059 r0 *1 2212.18,5608.1
X$65059 \$18 \$14633 \$17742 VSS INVR03
* cell instance $65069 r0 *1 2291.63,5608.1
X$65069 \$18 \$17732 \$16741 VSS INVR03
* cell instance $65074 m90 *1 2356.69,5608.1
X$65074 \$18105 \$18104 \$18 \$11886 VSS OR2101
* cell instance $65078 r0 *1 2373.49,5608.1
X$65078 \$18 \$14781 \$16612 VSS INVR02
* cell instance $65081 r0 *1 2396.73,5608.1
X$65081 \$18 \$16612 \$18109 VSS INVR02
* cell instance $65088 m90 *1 2488.28,5608.1
X$65088 \$18 \$10061 \$10061 VSS INVR06
* cell instance $65091 r0 *1 2496.65,5608.1
X$65091 \$17746 \$17448 \$18 \$10061 VSS OR2101
* cell instance $65093 r0 *1 2521,5608.1
X$65093 \$16166 \$18207 \$18113 \$18114 \$18206 \$17741 \$18 VSS NND501
* cell instance $65097 m90 *1 2606.17,5608.1
X$65097 \$18116 \$17744 \$18 \$17450 VSS OR2101
* cell instance $65101 r0 *1 2617.87,5608.1
X$65101 \$17851 \$18117 \$18 \$17748 VSS OR2101
* cell instance $65106 m90 *1 2670.96,5608.1
X$65106 \$18118 \$17140 \$18117 \$18 VSS NND201
* cell instance $65111 r0 *1 2686.78,5608.1
X$65111 \$11886 \$18119 \$18 \$17233 VSS OR2101
* cell instance $65116 r0 *1 2715.42,5608.1
X$65116 \$18 \$18121 \$17358 VSS INVR06
* cell instance $65119 r0 *1 2755.42,5608.1
X$65119 \$18 \$17850 \$17858 VSS INVR03
* cell instance $65125 r0 *1 2812.24,5608.1
X$65125 \$18 \$17838 \$18123 VSS INVR06
* cell instance $65126 r0 *1 2841.64,5608.1
X$65126 \$17078 \$18 \$17754 VSS INVR05
* cell instance $65129 m90 *1 2896.69,5608.1
X$65129 \$18 \$16194 \$18126 VSS INVR03
* cell instance $65131 r0 *1 2896.69,5608.1
X$65131 \$18 \$18126 \$18128 VSS INVR03
* cell instance $65138 r0 *1 2958.48,5608.1
X$65138 \$18 \$8212 \$17985 VSS INVR06
* cell instance $65139 r0 *1 2989.98,5608.1
X$65139 \$18 \$17762 \$17851 VSS INVR03
* cell instance $65142 r0 *1 3008.89,5608.1
X$65142 \$17851 \$18132 \$18 \$13378 VSS OR2101
* cell instance $65144 m90 *1 3059.89,5608.1
X$65144 \$18136 \$14512 \$18 \$11228 VSS OR2101
* cell instance $65148 m90 *1 3079.61,5608.1
X$65148 \$18137 \$18 \$12176 VSS INVR01
* cell instance $65150 m90 *1 3096.94,5608.1
X$65150 \$18 \$18140 \$16644 VSS INVR03
* cell instance $65152 r0 *1 3099.05,5608.1
X$65152 \$18123 \$18 \$17867 VSS INVR05
* cell instance $65153 r0 *1 3124.25,5608.1
X$65153 \$18 \$18123 \$17985 VSS INVR03
* cell instance $65154 m90 *1 3157.85,5608.1
X$65154 \$18 \$17469 \$17371 VSS INVR03
* cell instance $65157 r0 *1 3167.29,5608.1
X$65157 \$18 \$17765 \$18143 VSS INVR06
* cell instance $65158 r0 *1 3196.69,5608.1
X$65158 \$18 \$17765 \$17468 VSS INVR03
* cell instance $65431 r0 *1 5384.4,5608.1
X$65431 \$18 \$18146 \$17990 VSS INVR06
* cell instance $65435 r0 *1 5434.31,5608.1
X$65435 \$18 \$17476 \$17990 VSS INVR03
* cell instance $65871 r0 *1 156.73,5962.9
X$65871 \$18 \$19135 \$7474 VSS INVR06
* cell instance $65872 r0 *1 186.13,5962.9
X$65872 \$18 \$18904 \$19135 VSS INVR06
* cell instance $65875 r0 *1 222.48,5962.9
X$65875 \$18 \$19013 \$19138 VSS INVR02
* cell instance $65878 m90 *1 267.78,5962.9
X$65878 \$18 \$19140 \$19013 VSS INVR03
* cell instance $65880 r0 *1 267.78,5962.9
X$65880 \$18 \$19056 \$18909 VSS INVR02
* cell instance $65881 r0 *1 487.01,5962.9
X$65881 \$18 \$18918 \$18366 VSS INVR02
* cell instance $65883 r0 *1 505.97,5962.9
X$65883 \$18 \$18675 \$18581 VSS INVR02
* cell instance $65884 r0 *1 522.77,5962.9
X$65884 \$18 \$19146 \$18919 VSS INVR02
* cell instance $65885 m90 *1 556.83,5962.9
X$65885 \$18 \$19062 \$18753 VSS INVR03
* cell instance $65886 r0 *1 556.83,5962.9
X$65886 \$18 \$18921 \$18676 VSS INVR02
* cell instance $65889 m90 *1 600.79,5962.9
X$65889 \$18 \$18821 \$19062 VSS INVR03
* cell instance $65891 r0 *1 606.74,5962.9
X$65891 \$18 \$19063 \$19150 VSS INVR03
* cell instance $65894 r0 *1 627.02,5962.9
X$65894 \$18 \$19063 \$18821 VSS INVR03
* cell instance $65898 m90 *1 667.47,5962.9
X$65898 \$18 \$18582 \$19063 VSS INVR03
* cell instance $65900 m90 *1 687.05,5962.9
X$65900 \$18 \$19235 \$18527 VSS INVR03
* cell instance $65902 m90 *1 712,5962.9
X$65902 \$18 \$19156 \$19235 VSS INVR02
* cell instance $65905 r0 *1 729.54,5962.9
X$65905 \$18 \$18683 \$18387 VSS INVR03
* cell instance $65908 m90 *1 786.95,5962.9
X$65908 \$19155 \$18682 \$19153 \$19152 \$19066 \$18 VSS AND401
* cell instance $65909 m90 *1 803.76,5962.9
X$65909 \$18 \$19066 \$19156 VSS INVR02
* cell instance $65910 m90 *1 820.56,5962.9
X$65910 \$18 \$19159 \$19152 VSS INVR02
* cell instance $65911 m90 *1 841.56,5962.9
X$65911 \$19161 \$19155 \$18 \$19023 VSS OR2101
* cell instance $65914 r0 *1 848.58,5962.9
X$65914 \$18 \$18929 \$18050 VSS INVR03
* cell instance $65916 r0 *1 865.38,5962.9
X$65916 \$18 \$18933 \$19162 VSS INVR02
* cell instance $65917 r0 *1 882.18,5962.9
X$65917 \$18 \$18684 \$18590 VSS INVR02
* cell instance $65919 m90 *1 920.69,5962.9
X$65919 \$18 \$18760 \$19068 VSS INVR03
* cell instance $65920 r0 *1 920.7,5962.9
X$65920 \$18 \$19164 \$19023 VSS INVR02
* cell instance $65923 m90 *1 971.7,5962.9
X$65923 \$18931 \$18926 \$18 \$18590 VSS OR2101
* cell instance $65925 r0 *1 973.34,5962.9
X$65925 \$18 \$18760 \$19071 VSS INVR02
* cell instance $65927 m90 *1 1006.95,5962.9
X$65927 \$18 \$19166 \$19159 VSS INVR02
* cell instance $65928 r0 *1 1006.95,5962.9
X$65928 \$19168 \$19068 \$19049 \$18 VSS NND201
* cell instance $65931 m90 *1 1053.74,5962.9
X$65931 \$18826 \$19071 \$18942 \$18 VSS NND201
* cell instance $65933 r0 *1 1053.74,5962.9
X$65933 \$19166 \$19071 \$18938 \$18 VSS NND201
* cell instance $65934 r0 *1 1071.85,5962.9
X$65934 \$18528 \$19075 \$18 \$19023 VSS OR2101
* cell instance $65936 r0 *1 1092.86,5962.9
X$65936 \$18 \$19168 \$19171 VSS INVR02
* cell instance $65937 m90 *1 1127.21,5962.9
X$65937 \$19278 \$19172 \$19075 \$18 VSS NND201
* cell instance $65940 r0 *1 1134.42,5962.9
X$65940 \$18 \$19049 \$19076 VSS INVR02
* cell instance $65942 r0 *1 1151.22,5962.9
X$65942 \$18 \$19174 \$18945 VSS INVR02
* cell instance $65953 r0 *1 1244.83,5962.9
X$65953 \$18528 \$19177 \$18 \$19076 VSS OR2101
* cell instance $65954 r0 *1 1265.83,5962.9
X$65954 \$18941 \$19082 \$18 \$18528 VSS OR2101
* cell instance $65956 m90 *1 1311.95,5962.9
X$65956 \$19180 \$19178 \$18 \$19179 VSS OR2101
* cell instance $65959 m90 *1 1341.53,5962.9
X$65959 \$19180 \$19027 \$19177 \$18 VSS NND201
* cell instance $65960 m90 *1 1358.33,5962.9
X$65960 \$19181 \$14322 \$18606 \$18 VSS NND201
* cell instance $65961 m90 *1 1375.13,5962.9
X$65961 \$19183 \$19184 \$19082 \$18 VSS NND201
* cell instance $65962 m90 *1 1391.93,5962.9
X$65962 \$18 \$19185 \$19282 VSS INVR02
* cell instance $65966 m90 *1 1423.86,5962.9
X$65966 \$18 \$19187 \$19185 VSS INVR02
* cell instance $65968 m90 *1 1440.66,5962.9
X$65968 \$19184 \$18616 \$18532 \$18 VSS NND201
* cell instance $65971 m90 *1 1471.6,5962.9
X$65971 \$19027 \$19190 \$18532 \$18 VSS NND201
* cell instance $65975 r0 *1 1478.4,5962.9
X$65975 \$18696 \$18 \$18695 VSS INVR01
* cell instance $65977 m90 *1 1512.13,5962.9
X$65977 \$19187 \$18412 \$18532 \$18 VSS NND201
* cell instance $65978 m90 *1 1528.94,5962.9
X$65978 \$19193 \$19194 \$18532 \$18 VSS NND201
* cell instance $65979 r0 *1 1528.95,5962.9
X$65979 \$18 \$19195 \$19028 VSS INVR02
* cell instance $65987 m90 *1 1619.47,5962.9
X$65987 \$18084 \$19196 \$18 \$19197 VSS OR2101
* cell instance $65990 r0 *1 1630.02,5962.9
X$65990 \$18 \$19200 \$19190 \$17708 VSS AND201
* cell instance $65997 r0 *1 1694.15,5962.9
X$65997 \$19090 \$19202 \$18 \$19200 VSS OR2101
* cell instance $65998 m90 *1 1731.95,5962.9
X$65998 \$18 \$18969 \$19203 VSS INVR02
* cell instance $66001 m90 *1 1762.13,5962.9
X$66001 \$18 \$18416 \$19090 VSS INVR03
* cell instance $66003 r0 *1 1762.13,5962.9
X$66003 \$18 \$19028 \$18963 VSS INVR02
* cell instance $66004 m90 *1 1808.33,5962.9
X$66004 \$18 \$18699 \$19205 VSS INVR06
* cell instance $66007 m90 *1 1837.38,5962.9
X$66007 \$18 \$19207 \$19206 VSS INVR02
* cell instance $66020 r0 *1 1923.84,5962.9
X$66020 \$18 \$18971 \$19207 VSS INVR03
* cell instance $66021 r0 *1 1940.64,5962.9
X$66021 \$18 \$18626 \$19209 VSS INVR03
* cell instance $66035 r0 *1 2051.84,5962.9
X$66035 \$18 \$19209 \$18852 VSS INVR03
* cell instance $66092 r0 *1 2517.9,5962.9
X$66092 \$19214 \$19098 \$18 \$17746 VSS OR2101
* cell instance $66098 r0 *1 2562,5962.9
X$66098 \$18 \$19212 \$18105 VSS INVR02
* cell instance $66100 r0 *1 2578.8,5962.9
X$66100 \$18 \$19098 \$19213 VSS INVR02
* cell instance $66103 r0 *1 2608.51,5962.9
X$66103 \$15112 \$18 \$19213 VSS INVR05
* cell instance $66106 r0 *1 2647.41,5962.9
X$66106 \$18 \$18983 \$19214 VSS INVR02
* cell instance $66112 m90 *1 2714.73,5962.9
X$66112 \$18 \$19031 \$19100 VSS INVR02
* cell instance $66114 r0 *1 2714.73,5962.9
X$66114 \$18 \$19100 \$19212 VSS INVR02
* cell instance $66119 r0 *1 2763.9,5962.9
X$66119 \$18 \$18985 \$8212 \$19212 VSS AND201
* cell instance $66122 r0 *1 2794.5,5962.9
X$66122 \$18 \$12044 \$18986 VSS INVR06
* cell instance $66264 m90 *1 3982.22,5962.9
X$66264 \$18 \$19216 \$19231 VSS INVR06
* cell instance $66267 m90 *1 4006.81,5962.9
X$66267 \$18 \$19217 \$19231 VSS INVR03
* cell instance $66269 r0 *1 4006.81,5962.9
X$66269 \$18 \$6384 \$19217 VSS INVR02
* cell instance $66283 r0 *1 4125.74,5962.9
X$66283 \$18 \$18991 \$18992 VSS INVR03
* cell instance $66316 m90 *1 4415.31,5962.9
X$66316 \$18 \$19218 \$19107 VSS INVR06
* cell instance $66321 r0 *1 4431.01,5962.9
X$66321 \$18 \$19219 \$19107 VSS INVR03
* cell instance $66323 r0 *1 4447.81,5962.9
X$66323 \$18 \$5484 \$19219 VSS INVR02
* cell instance $66393 r0 *1 5017.82,5962.9
X$66393 \$18 \$14673 \$19221 VSS INVR03
* cell instance $66877 r0 *1 168.43,5785.5
X$66877 \$18 \$18669 \$18574 VSS INVR03
* cell instance $66880 m90 *1 219.04,5785.5
X$66880 \$18364 \$18576 \$18 \$18547 VSS OR2101
* cell instance $66881 r0 *1 219.04,5785.5
X$66881 \$18 \$924 \$18576 VSS INVR06
* cell instance $66882 r0 *1 249.52,5785.5
X$66882 \$18 \$18361 \$18547 VSS INVR03
* cell instance $66889 r0 *1 340.72,5785.5
X$66889 \$18723 \$18 \$18673 \$18580 VSS NOR201
* cell instance $66891 r0 *1 382.47,5785.5
X$66891 \$18 \$18723 \$18167 VSS INVR02
* cell instance $66896 m90 *1 499.67,5785.5
X$66896 \$18674 \$18 \$18366 \$18675 VSS NOR201
* cell instance $66902 r0 *1 526.93,5785.5
X$66902 \$18373 \$18 \$18581 VSS INVR01
* cell instance $66905 m90 *1 565.2,5785.5
X$66905 \$18 \$18676 \$18581 VSS INVR03
* cell instance $66907 m90 *1 603.35,5785.5
X$66907 \$18 \$18358 \$18526 VSS INVR06
* cell instance $66911 r0 *1 716.05,5785.5
X$66911 \$18 \$18678 \$18378 VSS INVR02
* cell instance $66914 m90 *1 760.88,5785.5
X$66914 \$18 \$18681 \$18680 VSS INVR02
* cell instance $66916 r0 *1 760.88,5785.5
X$66916 \$18732 \$17306 \$18379 \$18 VSS NND201
* cell instance $66917 r0 *1 777.68,5785.5
X$66917 \$18 \$18732 \$18382 VSS INVR02
* cell instance $66918 r0 *1 795.79,5785.5
X$66918 \$18682 \$17959 \$18387 \$18 VSS NND201
* cell instance $66922 r0 *1 825.79,5785.5
X$66922 \$18 \$17689 \$18683 VSS INVR02
* cell instance $66928 r0 *1 865.49,5785.5
X$66928 \$18 \$15637 \$18684 VSS INVR02
* cell instance $66930 r0 *1 890.58,5785.5
X$66930 \$18 \$18685 \$15637 VSS INVR02
* cell instance $66935 m90 *1 958.86,5785.5
X$66935 \$18582 \$18 \$18391 VSS INVR05
* cell instance $66938 r0 *1 972.07,5785.5
X$66938 \$18760 \$18 \$17410 VSS INVR05
* cell instance $66941 r0 *1 1002.07,5785.5
X$66941 \$18 \$18392 \$18663 VSS INVR03
* cell instance $66944 r0 *1 1028.63,5785.5
X$66944 \$18 \$18528 \$18663 VSS INVR06
* cell instance $66947 r0 *1 1070.5,5785.5
X$66947 \$18590 \$18593 \$18 \$18528 VSS OR2101
* cell instance $66950 m90 *1 1125.06,5785.5
X$66950 \$17017 \$18689 \$18 \$18591 VSS OR2101
* cell instance $66951 m90 *1 1141.86,5785.5
X$66951 \$18591 \$18400 \$18593 \$18 VSS NND201
* cell instance $66952 r0 *1 1142.4,5785.5
X$66952 \$18 \$18394 \$18397 VSS INVR02
* cell instance $66964 m90 *1 1268.24,5785.5
X$66964 \$17017 \$18598 \$18 \$18297 VSS OR2101
* cell instance $66965 r0 *1 1268.25,5785.5
X$66965 \$18 \$18601 \$18292 VSS INVR03
* cell instance $66974 m90 *1 1360.25,5785.5
X$66974 \$18691 \$18403 \$18603 \$18 VSS NND201
* cell instance $66978 r0 *1 1375.66,5785.5
X$66978 \$18 \$17019 \$18401 VSS INVR03
* cell instance $66980 r0 *1 1392.46,5785.5
X$66980 \$18 \$18532 \$17019 VSS INVR06
* cell instance $66981 r0 *1 1421.86,5785.5
X$66981 \$18 \$17019 \$18606 VSS INVR03
* cell instance $66982 m90 *1 1455.62,5785.5
X$66982 \$18693 \$18607 \$18532 \$18 VSS NND201
* cell instance $66984 m90 *1 1476.42,5785.5
X$66984 \$18399 \$18077 \$18532 \$18 VSS NND201
* cell instance $66987 r0 *1 1489.62,5785.5
X$66987 \$18 \$18694 \$18695 VSS INVR02
* cell instance $66992 r0 *1 1520.76,5785.5
X$66992 \$18414 \$18611 \$18 \$18571 VSS OR2101
* cell instance $66993 r0 *1 1541.76,5785.5
X$66993 \$18 \$18571 \$18696 \$17708 VSS AND201
* cell instance $66997 r0 *1 1581.04,5785.5
X$66997 \$18 \$18611 \$18570 VSS INVR02
* cell instance $66998 r0 *1 1598.84,5785.5
X$66998 \$18 \$18569 \$18616 VSS INVR02
* cell instance $67000 r0 *1 1616.58,5785.5
X$67000 \$18415 \$18417 \$18 \$18617 VSS OR2101
* cell instance $67001 r0 *1 1637.58,5785.5
X$67001 \$18 \$18570 \$18620 VSS INVR03
* cell instance $67008 r0 *1 1697.59,5785.5
X$67008 \$18 \$18622 \$18569 VSS INVR02
* cell instance $67014 r0 *1 1931.86,5785.5
X$67014 \$18 \$18426 \$18626 VSS INVR03
* cell instance $67031 r0 *1 2203.13,5785.5
X$67031 \$18 \$13584 \$18703 VSS INVR02
* cell instance $67034 m90 *1 2249.93,5785.5
X$67034 \$17226 \$18 \$18557 VSS INVR05
* cell instance $67035 r0 *1 2249.93,5785.5
X$67035 \$18704 \$18 \$14089 VSS INVR01
* cell instance $67037 m90 *1 2408.47,5785.5
X$67037 \$14631 \$16151 \$14781 \$18637 \$18557 \$17040 \$18 VSS AND501
* cell instance $67040 r0 *1 2416.91,5785.5
X$67040 \$18 \$18435 \$18638 VSS INVR06
* cell instance $67064 m90 *1 2643.47,5785.5
X$67064 \$18540 \$18 \$18714 VSS INVR01
* cell instance $67065 r0 *1 2643.47,5785.5
X$67065 \$18 \$16625 \$18773 VSS INVR02
* cell instance $67066 r0 *1 2660.27,5785.5
X$67066 \$18706 \$18642 \$18113 \$10061 \$18540 \$18 VSS AOI401
* cell instance $67067 r0 *1 2707.23,5785.5
X$67067 \$18 \$17055 \$18641 VSS INVR03
* cell instance $67070 m90 *1 2753.44,5785.5
X$67070 \$18 \$18708 \$18642 VSS INVR03
* cell instance $67075 m90 *1 2807.76,5785.5
X$67075 \$18 \$18447 \$8212 \$18543 VSS AND201
* cell instance $67077 m90 *1 2824.57,5785.5
X$67077 \$18 \$18543 \$18708 VSS INVR02
* cell instance $67082 m90 *1 2875.16,5785.5
X$67082 \$18 \$18710 \$18711 \$18543 VSS AND201
* cell instance $67083 r0 *1 2875.16,5785.5
X$67083 \$18 \$18712 \$18543 VSS INVR03
* cell instance $67084 m90 *1 2908.76,5785.5
X$67084 \$18711 \$17364 \$18645 \$18 VSS NND201
* cell instance $67089 m90 *1 2948.97,5785.5
X$67089 \$18 \$18715 \$18714 VSS INVR02
* cell instance $67093 r0 *1 2965.42,5785.5
X$67093 \$18715 \$18451 \$15128 \$18 VSS NND201
* cell instance $67096 r0 *1 2993.81,5785.5
X$67096 \$18 \$18457 \$18450 VSS INVR03
* cell instance $67098 m90 *1 3031.61,5785.5
X$67098 \$18641 \$18645 \$18 \$18546 VSS OR2101
* cell instance $67102 r0 *1 3046.95,5785.5
X$67102 \$18 \$14512 \$18712 VSS INVR02
* cell instance $67104 m90 *1 3076.35,5785.5
X$67104 \$18546 \$18 \$18651 VSS INVR01
* cell instance $67108 m90 *1 3113.82,5785.5
X$67108 \$18651 \$18 \$11228 VSS INVR01
* cell instance $67228 r0 *1 4057.21,5785.5
X$67228 \$18 \$9382 \$18653 VSS INVR03
* cell instance $67232 m90 *1 4120.81,5785.5
X$67232 \$18 \$18718 \$18654 VSS INVR06
* cell instance $67831 r0 *1 42.4,4898.5
X$67831 \$18 \$7474 \$7474 VSS INVR02
* cell instance $67834 r0 *1 71.87,4898.5
X$67834 \$18 \$14574 \$12850 VSS INVR06
* cell instance $67835 r0 *1 101.27,4898.5
X$67835 \$18 \$12850 \$13837 VSS INVR03
* cell instance $67843 m90 *1 192.91,4898.5
X$67843 \$14014 \$12853 \$18 \$14440 VSS OR2101
* cell instance $67845 r0 *1 193.52,4898.5
X$67845 \$18 \$14577 \$14441 VSS INVR06
* cell instance $67846 m90 *1 239.72,4898.5
X$67846 \$18 \$14020 \$12388 VSS INVR03
* cell instance $67849 r0 *1 252.91,4898.5
X$67849 \$18 \$14578 \$14579 VSS INVR02
* cell instance $67859 r0 *1 330.32,4898.5
X$67859 \$8538 \$14018 \$12860 \$18 \$12391 VSS OR3101
* cell instance $67861 m90 *1 379.8,4898.5
X$67861 \$14582 \$14445 \$12270 \$18 VSS NND201
* cell instance $67866 m90 *1 407.17,4898.5
X$67866 \$14024 \$18 \$14035 VSS INVR01
* cell instance $67870 m90 *1 449.72,4898.5
X$67870 \$18 \$14036 \$14384 VSS INVR03
* cell instance $67875 r0 *1 463.78,4898.5
X$67875 \$18 \$9995 \$14384 VSS INVR06
* cell instance $67882 m90 *1 557.15,4898.5
X$67882 \$13075 \$14587 \$18 \$13077 VSS OR2101
* cell instance $67883 r0 *1 557.15,4898.5
X$67883 \$18 \$14588 \$14036 VSS INVR02
* cell instance $67884 r0 *1 573.95,4898.5
X$67884 \$18 \$14032 \$14588 VSS INVR02
* cell instance $67887 r0 *1 596.4,4898.5
X$67887 \$18 \$13077 \$13389 VSS INVR04
* cell instance $67890 r0 *1 623.85,4898.5
X$67890 \$14037 \$18 \$14456 \$13077 VSS NOR201
* cell instance $67893 m90 *1 684.61,4898.5
X$67893 \$14456 \$14457 \$18 \$13392 VSS OR2101
* cell instance $67894 r0 *1 684.61,4898.5
X$67894 \$18 \$14314 \$12267 VSS INVR03
* cell instance $67897 r0 *1 714.16,4898.5
X$67897 \$18 \$14039 \$13858 VSS INVR02
* cell instance $67898 r0 *1 732.2,4898.5
X$67898 \$18 \$12443 \$7474 VSS INVR03
* cell instance $67911 r0 *1 828.47,4898.5
X$67911 \$18 \$14041 \$14462 VSS INVR03
* cell instance $67913 r0 *1 845.27,4898.5
X$67913 \$18 \$14043 \$13860 VSS INVR02
* cell instance $67920 r0 *1 901.05,4898.5
X$67920 \$18 \$14464 \$14463 VSS INVR04
* cell instance $67922 r0 *1 1077.46,4898.5
X$67922 \$18 \$14047 \$14051 VSS INVR03
* cell instance $67928 r0 *1 1126.13,4898.5
X$67928 \$14469 \$14318 \$18 \$12421 VSS OR2101
* cell instance $67931 m90 *1 1177.63,4898.5
X$67931 \$14052 \$14317 \$18 \$14599 VSS OR2101
* cell instance $67933 m90 *1 1194.43,4898.5
X$67933 \$14599 \$14471 \$14318 \$18 VSS NND201
* cell instance $67935 r0 *1 1200.33,4898.5
X$67935 \$11152 \$14054 \$18 \$14321 VSS OR2101
* cell instance $67938 r0 *1 1223.44,4898.5
X$67938 \$14602 \$18 \$14601 VSS INVR01
* cell instance $67939 r0 *1 1236.34,4898.5
X$67939 \$18 \$12285 \$14475 VSS INVR02
* cell instance $67940 r0 *1 1253.91,4898.5
X$67940 \$14061 \$18 \$14475 VSS INVR05
* cell instance $67944 m90 *1 1312.71,4898.5
X$67944 \$14321 \$18 \$14057 VSS INVR01
* cell instance $67952 r0 *1 1356.6,4898.5
X$67952 \$14322 \$18 \$13418 VSS INVR05
* cell instance $67961 m90 *1 1455.63,4898.5
X$67961 \$18 \$14607 \$14605 VSS INVR02
* cell instance $67966 m90 *1 1486.54,4898.5
X$67966 \$18 \$14063 \$14607 VSS INVR02
* cell instance $67968 r0 *1 1489.51,4898.5
X$67968 \$18 \$7162 \$13564 VSS INVR06
* cell instance $67971 r0 *1 1532.17,4898.5
X$67971 \$18 \$14478 \$14605 \$11858 VSS AND201
* cell instance $67975 r0 *1 1573.42,4898.5
X$67975 \$18 \$11858 \$14479 VSS INVR03
* cell instance $67978 r0 *1 1603.39,4898.5
X$67978 \$18 \$14479 \$14480 VSS INVR03
* cell instance $67990 m90 *1 1718.07,4898.5
X$67990 \$18 \$14611 \$13570 VSS INVR03
* cell instance $67995 m90 *1 1752.76,4898.5
X$67995 \$18 \$14482 \$14611 VSS INVR02
* cell instance $68009 r0 *1 1994.55,4898.5
X$68009 \$18 \$14483 \$14083 VSS INVR02
* cell instance $68012 r0 *1 2169.63,4898.5
X$68012 \$18 \$14627 \$14624 VSS INVR03
* cell instance $68014 m90 *1 2240.97,4898.5
X$68014 \$14084 \$14085 \$13587 \$14326 \$14083 \$14631 \$18 VSS NND501
* cell instance $68018 r0 *1 2248.5,4898.5
X$68018 \$18 \$12308 \$14331 VSS INVR06
* cell instance $68019 r0 *1 2277.9,4898.5
X$68019 \$18 \$14331 \$14633 VSS INVR06
* cell instance $68020 r0 *1 2307.3,4898.5
X$68020 \$11180 \$18 \$14082 VSS INVR05
* cell instance $68024 m90 *1 2376.46,4898.5
X$68024 \$18 \$13435 \$7288 VSS INVR06
* cell instance $68025 m90 *1 2401.66,4898.5
X$68025 \$13102 \$18 \$14335 \$13882 \$14095 VSS ADNR01
* cell instance $68026 m90 *1 2418.46,4898.5
X$68026 \$18 \$11890 \$14636 VSS INVR02
* cell instance $68027 r0 *1 2418.46,4898.5
X$68027 \$18 \$14637 \$14638 VSS INVR02
* cell instance $68028 r0 *1 2436.45,4898.5
X$68028 \$14498 \$14095 \$12461 \$18 VSS NND201
* cell instance $68036 r0 *1 2494.81,4898.5
X$68036 \$11200 \$18 \$14496 \$13440 VSS NOR201
* cell instance $68037 r0 *1 2528.41,4898.5
X$68037 \$18 \$11886 \$14218 VSS INVR06
* cell instance $68038 r0 *1 2558.41,4898.5
X$68038 \$18 \$14498 \$14643 VSS INVR03
* cell instance $68044 m90 *1 2627.25,4898.5
X$68044 \$14220 \$13440 \$18 \$12308 VSS OR2101
* cell instance $68047 r0 *1 2629.59,4898.5
X$68047 \$14342 \$18 \$13440 \$14496 VSS NOR201
* cell instance $68048 m90 *1 2696.79,4898.5
X$68048 \$14496 \$18 \$14103 \$11886 VSS NOR201
* cell instance $68051 m90 *1 2723.53,4898.5
X$68051 \$18 \$14845 \$14335 VSS INVR02
* cell instance $68056 r0 *1 2757.64,4898.5
X$68056 \$18 \$14935 \$13611 VSS INVR03
* cell instance $68063 m90 *1 2831.45,4898.5
X$68063 \$18 \$14350 \$13607 VSS INVR03
* cell instance $68071 r0 *1 2888.96,4898.5
X$68071 \$14103 \$14507 \$18 \$14348 VSS OR2101
* cell instance $68075 m90 *1 2956.67,4898.5
X$68075 \$14647 \$18 \$13366 \$11390 VSS NOR201
* cell instance $68077 m90 *1 2973.47,4898.5
X$68077 \$18 \$14118 \$14508 VSS INVR03
* cell instance $68079 m90 *1 3003.57,4898.5
X$68079 \$18 \$12328 \$14510 \$11216 VSS AND201
* cell instance $68080 r0 *1 3003.57,4898.5
X$68080 \$13613 \$18 \$12328 VSS INVR01
* cell instance $68081 m90 *1 3062.37,4898.5
X$68081 \$18 \$13593 \$14512 VSS INVR06
* cell instance $68083 r0 *1 3063.89,4898.5
X$68083 \$14653 \$18 \$11916 \$10074 VSS NOR201
* cell instance $68087 m90 *1 3134.79,4898.5
X$68087 \$18 \$14118 \$14350 VSS INVR03
* cell instance $68090 r0 *1 3145.16,4898.5
X$68090 \$14117 \$18 \$13126 \$10074 VSS NOR201
* cell instance $68092 r0 *1 3183.61,4898.5
X$68092 \$14656 \$18 \$12480 VSS INVR01
* cell instance $68094 r0 *1 3201.43,4898.5
X$68094 \$14130 \$14517 \$13126 \$18 \$14657 VSS OR3101
* cell instance $68098 r0 *1 3234,4898.5
X$68098 \$18 \$14130 \$13139 VSS INVR06
* cell instance $68099 m90 *1 3286.13,4898.5
X$68099 \$13137 \$14662 \$18 \$12945 VSS OR2101
* cell instance $68101 r0 *1 3286.13,4898.5
X$68101 \$18 \$14124 \$14126 VSS INVR02
* cell instance $68103 m90 *1 3327.25,4898.5
X$68103 \$14522 \$14663 \$18 \$14391 VSS OR2101
* cell instance $68105 m90 *1 3344.05,4898.5
X$68105 \$18 \$14665 \$14664 VSS INVR02
* cell instance $68106 r0 *1 3344.05,4898.5
X$68106 \$18 \$12953 \$14523 VSS INVR03
* cell instance $68107 m90 *1 3379.73,4898.5
X$68107 \$14391 \$14526 \$13452 \$18 VSS NND201
* cell instance $68110 m90 *1 3403.06,4898.5
X$68110 \$11226 \$14526 \$18 \$14954 VSS OR2101
* cell instance $68112 r0 *1 3412.45,4898.5
X$68112 \$18 \$14709 \$11226 \$14130 VSS AND201
* cell instance $68116 r0 *1 3448.42,4898.5
X$68116 \$18 \$14709 \$13626 VSS INVR03
* cell instance $68204 m90 *1 4192.39,4898.5
X$68204 \$18 \$14667 \$7073 VSS INVR06
* cell instance $68221 r0 *1 4309.47,4898.5
X$68221 \$18 \$14668 \$14364 VSS INVR03
* cell instance $68242 m90 *1 4503.45,4898.5
X$68242 \$18 \$14669 \$7206 VSS INVR06
* cell instance $68291 r0 *1 4875.16,4898.5
X$68291 \$18 \$14364 \$14135 VSS INVR03
* cell instance $68312 r0 *1 5037.77,4898.5
X$68312 \$18 \$14139 \$13631 VSS INVR02
* cell instance $68314 r0 *1 5059.74,4898.5
X$68314 \$18 \$14139 \$14702 VSS INVR02
* cell instance $68316 r0 *1 5076.54,4898.5
X$68316 \$18 \$14702 \$14532 VSS INVR03
* cell instance $68331 r0 *1 5196.24,4898.5
X$68331 \$18 \$14672 \$13473 VSS INVR06
* cell instance $68332 r0 *1 5226.24,4898.5
X$68332 \$18 \$13646 \$13471 VSS INVR06
* cell instance $68333 r0 *1 5256.25,4898.5
X$68333 \$18 \$14673 \$14385 VSS INVR06
* cell instance $68334 r0 *1 5285.65,4898.5
X$68334 \$18 \$14385 \$13476 VSS INVR06
* cell instance $68335 r0 *1 5315.65,4898.5
X$68335 \$18 \$13634 \$13152 VSS INVR06
* cell instance $68341 r0 *1 5381.5,4898.5
X$68341 \$14145 \$18 \$14146 \$14144 VSS NOR201
* cell instance $68412 r0 *1 5976.05,4898.5
X$68412 \$18 \$13634 \$14148 VSS INVR03
* cell instance $68427 r0 *1 6105.5,4898.5
X$68427 \$18 \$13646 \$13646 VSS INVR02
* cell instance $68428 r0 *1 6122.3,4898.5
X$68428 \$18 \$13187 \$13647 VSS INVR02
* cell instance $68432 r0 *1 6164.45,4898.5
X$68432 \$18 \$13649 \$14547 VSS INVR03
* cell instance $68465 r0 *1 6412.58,4898.5
X$68465 \$18 \$14677 \$14547 VSS INVR06
* cell instance $68475 m90 *1 6535.04,4898.5
X$68475 \$14962 \$18 \$14160 VSS INVR05
* cell instance $68477 m90 *1 6556.04,4898.5
X$68477 \$18 \$14160 \$12777 VSS INVR04
* cell instance $68483 r0 *1 6597.11,4898.5
X$68483 \$18 \$14677 \$14157 VSS INVR03
* cell instance $68487 r0 *1 6630.02,4898.5
X$68487 \$8743 \$14367 \$14368 \$I331335 \$14553 \$18 VSS DFCL11
* cell instance $68492 r0 *1 6760.5,4898.5
X$68492 \$18 \$14677 \$13651 VSS INVR03
* cell instance $68499 r0 *1 6810.9,4898.5
X$68499 \$18 \$14682 \$14554 VSS INVR06
* cell instance $68511 m90 *1 6953.53,4898.5
X$68511 \$18 \$13654 \$13657 \$14683 VSS AND201
* cell instance $68513 m90 *1 7000.9,4898.5
X$68513 \$13660 \$13784 \$14683 \$18 VSS XNR201
* cell instance $68518 r0 *1 7022.19,4898.5
X$68518 \$18 \$14684 \$14555 VSS INVR03
* cell instance $68521 r0 *1 7041.08,4898.5
X$68521 \$18 \$14170 \$14684 VSS INVR02
* cell instance $68523 r0 *1 7067.24,4898.5
X$68523 \$18 \$14682 \$14375 VSS INVR03
* cell instance $68526 r0 *1 7089.6,4898.5
X$68526 \$18 \$13663 \$14168 VSS INVR03
* cell instance $68541 r0 *1 7193.64,4898.5
X$68541 \$18 \$14175 \$14375 VSS INVR06
* cell instance $68628 r0 *1 7904.88,4898.5
X$68628 \$18 \$14176 \$14559 VSS INVR06
* cell instance $68629 r0 *1 7934.85,4898.5
X$68629 \$18 \$14158 \$14173 VSS INVR06
* cell instance $68744 r0 *1 8864.15,4898.5
X$68744 \$18 \$14689 \$14370 VSS INVR02
* cell instance $68747 r0 *1 236.78,6317.7
X$68747 \$18 \$19744 \$19366 VSS INVR03
* cell instance $68765 r0 *1 385.19,6317.7
X$68765 \$18 \$19808 \$19778 VSS INVR03
* cell instance $68767 r0 *1 485.99,6317.7
X$68767 \$19809 \$18 \$5730 VSS INVR05
* cell instance $68774 r0 *1 553.97,6317.7
X$68774 \$19811 \$18 \$19778 VSS INVR05
* cell instance $68775 r0 *1 579.17,6317.7
X$68775 \$18 \$13532 \$19811 VSS INVR06
* cell instance $68834 r0 *1 1067.16,6317.7
X$68834 \$18 \$19449 \$19782 VSS INVR06
* cell instance $68840 m90 *1 1147.87,6317.7
X$68840 \$19814 \$19181 \$19550 \$18 VSS NND201
* cell instance $68841 m90 *1 1166.54,6317.7
X$68841 \$18 \$19816 \$19782 VSS INVR03
* cell instance $68843 m90 *1 1183.34,6317.7
X$68843 \$18 \$19818 \$19757 VSS INVR02
* cell instance $68844 r0 *1 1183.35,6317.7
X$68844 \$18 \$19737 \$19640 VSS INVR06
* cell instance $68845 m90 *1 1229.59,6317.7
X$68845 \$19818 \$19282 \$19641 \$18 VSS NND201
* cell instance $68846 r0 *1 1229.6,6317.7
X$68846 \$18 \$11696 \$19821 VSS INVR06
* cell instance $68849 r0 *1 1272.79,6317.7
X$68849 \$18 \$19760 \$19822 VSS INVR03
* cell instance $68851 r0 *1 1289.59,6317.7
X$68851 \$18 \$19822 \$19761 VSS INVR02
* cell instance $68855 m90 *1 1348.27,6317.7
X$68855 \$18 \$19787 \$19172 VSS INVR03
* cell instance $68867 r0 *1 1512.62,6317.7
X$68867 \$18 \$19825 \$19790 VSS INVR06
* cell instance $68873 r0 *1 1576.82,6317.7
X$68873 \$19597 \$18 \$19647 VSS INVR05
* cell instance $68874 r0 *1 1602.02,6317.7
X$68874 \$18 \$18419 \$19767 VSS INVR02
* cell instance $68875 r0 *1 1618.91,6317.7
X$68875 \$18 \$19724 \$19828 VSS INVR03
* cell instance $68876 r0 *1 1637.81,6317.7
X$68876 \$18 \$19828 \$19399 VSS INVR03
* cell instance $69967 r0 *1 1491,6495.1
X$69967 \$18 \$13564 \$19825 VSS INVR06
* cell instance $70360 m90 *1 4676.6,6495.1
X$70360 \$18 \$19859 \$17474 VSS INVR06
* cell instance $70888 r0 *1 216.21,6140.3
X$70888 \$18 \$19429 \$19365 \$18358 VSS AND201
* cell instance $70889 r0 *1 241.42,6140.3
X$70889 \$18 \$19517 \$18360 VSS INVR02
* cell instance $70890 r0 *1 258.22,6140.3
X$70890 \$18 \$19138 \$19560 VSS INVR02
* cell instance $70892 r0 *1 283.91,6140.3
X$70892 \$18 \$19560 \$19615 VSS INVR02
* cell instance $70896 r0 *1 314.61,6140.3
X$70896 \$18 \$18673 \$19616 VSS INVR02
* cell instance $70899 m90 *1 377.59,6140.3
X$70899 \$19617 \$18 \$19619 \$19618 VSS NOR201
* cell instance $70901 r0 *1 382.39,6140.3
X$70901 \$18 \$19433 \$19014 \$19562 VSS AND201
* cell instance $70903 m90 *1 453.74,6140.3
X$70903 \$19618 \$19562 \$19375 \$18 VSS XNR201
* cell instance $70905 r0 *1 458.28,6140.3
X$70905 \$19437 \$18 \$19372 VSS INVR05
* cell instance $70915 r0 *1 546.01,6140.3
X$70915 \$18 \$18581 \$19562 VSS INVR02
* cell instance $70923 r0 *1 708.81,6140.3
X$70923 \$19378 \$18922 \$19625 \$18 VSS NND201
* cell instance $70927 m90 *1 754.93,6140.3
X$70927 \$18 \$19524 \$19440 VSS INVR02
* cell instance $70928 m90 *1 771.73,6140.3
X$70928 \$19627 \$17959 \$19625 \$18 VSS NND201
* cell instance $70931 m90 *1 817.08,6140.3
X$70931 \$19632 \$19627 \$18383 \$19612 \$19629 \$18 VSS AND401
* cell instance $70935 m90 *1 851.2,6140.3
X$70935 \$19380 \$19379 \$18 \$19542 VSS OR2101
* cell instance $70939 r0 *1 863.43,6140.3
X$70939 \$18 \$19162 \$19673 VSS INVR02
* cell instance $70940 r0 *1 880.23,6140.3
X$70940 \$18 \$19673 \$19672 VSS INVR02
* cell instance $70943 r0 *1 908.1,6140.3
X$70943 \$18 \$19672 \$19586 VSS INVR02
* cell instance $70945 m90 *1 941.7,6140.3
X$70945 \$18 \$19634 \$19542 VSS INVR02
* cell instance $70948 r0 *1 948.22,6140.3
X$70948 \$18 \$7568 \$19337 VSS INVR06
* cell instance $70951 r0 *1 991.21,6140.3
X$70951 \$18 \$19385 \$19674 VSS INVR02
* cell instance $70953 r0 *1 1008.01,6140.3
X$70953 \$18 \$19674 \$19450 VSS INVR03
* cell instance $70957 r0 *1 1096.21,6140.3
X$70957 \$18 \$18813 \$19449 VSS INVR06
* cell instance $70958 r0 *1 1125.61,6140.3
X$70958 \$18528 \$19550 \$18 \$19586 VSS OR2101
* cell instance $70959 m90 *1 1163.41,6140.3
X$70959 \$19612 \$19068 \$19450 \$18 VSS NND201
* cell instance $70960 m90 *1 1180.21,6140.3
X$70960 \$18 \$19455 \$19551 VSS INVR03
* cell instance $70961 r0 *1 1180.22,6140.3
X$70961 \$19640 \$18 \$19590 VSS INVR05
* cell instance $70964 r0 *1 1211.58,6140.3
X$70964 \$19591 \$19641 \$18 \$18528 VSS OR2101
* cell instance $70967 r0 *1 1249.39,6140.3
X$70967 \$18 \$19528 \$19592 VSS INVR03
* cell instance $70969 r0 *1 1275.79,6140.3
X$70969 \$18 \$19392 \$19460 VSS INVR02
* cell instance $70982 r0 *1 1410.54,6140.3
X$70982 \$19179 \$19645 \$18 \$18954 VSS OR2101
* cell instance $70984 m90 *1 1603.74,6140.3
X$70984 \$18 \$19401 \$19468 VSS INVR02
* cell instance $70985 r0 *1 1603.74,6140.3
X$70985 \$18 \$19647 \$19471 VSS INVR06
* cell instance $70991 r0 *1 1801.49,6140.3
X$70991 \$18 \$19602 \$19651 VSS INVR02
* cell instance $71126 r0 *1 2879.97,6140.3
X$71126 \$18 \$19408 \$19603 VSS INVR06
* cell instance $71127 r0 *1 2909.37,6140.3
X$71127 \$18 \$19647 \$19603 VSS INVR02
* cell instance $71283 r0 *1 4156.73,6140.3
X$71283 \$19654 \$18 \$19604 VSS INVR05
* cell instance $71284 r0 *1 4181.93,6140.3
X$71284 \$18 \$14667 \$19605 VSS INVR03
* cell instance $71288 r0 *1 4212.9,6140.3
X$71288 \$18 \$19656 \$19482 VSS INVR06
* cell instance $71522 m90 *1 6131.21,6140.3
X$71522 \$18 \$19657 \$19533 VSS INVR06
* cell instance $71596 r0 *1 6707.4,6140.3
X$71596 \$19533 \$18 \$17773 VSS INVR05
* cell instance $71867 r0 *1 158.12,5430.7
X$71867 \$18 \$16983 \$16980 VSS INVR03
* cell instance $71869 r0 *1 178.05,5430.7
X$71869 \$18 \$17254 \$17385 VSS INVR02
* cell instance $71871 r0 *1 194.85,5430.7
X$71871 \$18 \$16515 \$16986 VSS INVR03
* cell instance $71874 r0 *1 229.67,5430.7
X$71874 \$18 \$16986 \$17299 VSS INVR03
* cell instance $71878 r0 *1 259.93,5430.7
X$71878 \$17512 \$17299 \$16985 \$18 VSS XNR201
* cell instance $71880 r0 *1 299.13,5430.7
X$71880 \$18 \$17386 \$17387 VSS INVR02
* cell instance $71885 m90 *1 364.72,5430.7
X$71885 \$18 \$17388 \$17118 VSS INVR06
* cell instance $71887 r0 *1 465.52,5430.7
X$71887 \$18 \$17302 \$17121 VSS INVR02
* cell instance $71889 r0 *1 589.07,5430.7
X$71889 \$18 \$17394 \$17395 VSS INVR02
* cell instance $71893 r0 *1 719.86,5430.7
X$71893 \$17399 \$16535 \$17306 \$18 VSS NND201
* cell instance $71899 m90 *1 817.07,5430.7
X$71899 \$17401 \$17220 \$17309 \$17394 \$15637 \$17519 \$18 VSS NND501
* cell instance $71904 m90 *1 845.13,5430.7
X$71904 \$17220 \$18 \$17403 VSS INVR01
* cell instance $71906 m90 *1 861.93,5430.7
X$71906 \$18 \$17491 \$17218 VSS INVR03
* cell instance $71909 m90 *1 889.41,5430.7
X$71909 \$18 \$16554 \$17491 VSS INVR02
* cell instance $71913 m90 *1 920.04,5430.7
X$71913 \$18 \$17312 \$16554 VSS INVR02
* cell instance $71915 m90 *1 961.74,5430.7
X$71915 \$17006 \$17002 \$17399 \$17406 \$17312 \$18 VSS AND401
* cell instance $71917 m90 *1 978.54,5430.7
X$71917 \$16702 \$17277 \$15059 \$18 VSS NND201
* cell instance $71920 m90 *1 1011.24,5430.7
X$71920 \$17410 \$18 \$15630 VSS INVR05
* cell instance $71923 r0 *1 1015.44,5430.7
X$71923 \$18 \$15630 \$17411 VSS INVR02
* cell instance $71924 m90 *1 1044.84,5430.7
X$71924 \$17277 \$18 \$15630 VSS INVR01
* cell instance $71925 m90 *1 1062.24,5430.7
X$71925 \$18 \$17010 \$17413 VSS INVR02
* cell instance $71927 r0 *1 1071.46,5430.7
X$71927 \$18 \$17413 \$17222 VSS INVR02
* cell instance $71931 m90 *1 1112.76,5430.7
X$71931 \$18 \$17417 \$17412 VSS INVR02
* cell instance $71934 r0 *1 1122.24,5430.7
X$71934 \$18 \$17418 \$17419 VSS INVR02
* cell instance $71940 r0 *1 1207.79,5430.7
X$71940 \$18 \$17419 \$17279 VSS INVR02
* cell instance $71943 r0 *1 1237.8,5430.7
X$71943 \$18 \$14601 \$17417 VSS INVR02
* cell instance $71945 r0 *1 1254.6,5430.7
X$71945 \$18 \$17425 \$16889 VSS INVR03
* cell instance $71949 r0 *1 1287.27,5430.7
X$71949 \$17279 \$17283 \$18 \$17323 VSS OR2101
* cell instance $71951 r0 *1 1310.16,5430.7
X$71951 \$18 \$15652 \$17323 VSS INVR03
* cell instance $71955 r0 *1 1337.62,5430.7
X$71955 \$17222 \$16715 \$18 \$17323 VSS OR2101
* cell instance $71956 m90 *1 1375.42,5430.7
X$71956 \$17429 \$17021 \$17283 \$18 VSS NND201
* cell instance $71960 r0 *1 1390.9,5430.7
X$71960 \$18 \$17328 \$17430 VSS INVR02
* cell instance $71965 r0 *1 1520.29,5430.7
X$71965 \$18 \$17028 \$17022 \$14065 VSS AND201
* cell instance $71967 r0 *1 1549.77,5430.7
X$71967 \$18 \$14065 \$17334 VSS INVR03
* cell instance $71977 m90 *1 1645.35,5430.7
X$71977 \$18 \$16138 \$17433 VSS INVR02
* cell instance $71983 r0 *1 1680.4,5430.7
X$71983 \$18 \$17029 \$17026 VSS INVR02
* cell instance $71985 r0 *1 1697.2,5430.7
X$71985 \$18 \$16895 \$17434 \$16582 VSS AND201
* cell instance $71988 m90 *1 1749.26,5430.7
X$71988 \$18 \$17595 \$17434 VSS INVR02
* cell instance $72014 m90 *1 2091.36,5430.7
X$72014 \$14920 \$16211 \$11200 \$17437 \$17346 \$14624 \$18 VSS NND501
* cell instance $72021 r0 *1 2130.56,5430.7
X$72021 \$18 \$17032 \$17206 VSS INVR02
* cell instance $72029 r0 *1 2190.04,5430.7
X$72029 \$18 \$15097 \$17036 VSS INVR03
* cell instance $72033 m90 *1 2271.46,5430.7
X$72033 \$15819 \$16750 \$17346 \$14291 \$17039 \$15265 \$18 VSS NND501
* cell instance $72034 m90 *1 2313.46,5430.7
X$72034 \$16155 \$13752 \$17035 \$16302 \$17441 \$17034 \$18 VSS AND501
* cell instance $72044 r0 *1 2374.66,5430.7
X$72044 \$18 \$11876 \$17350 VSS INVR06
* cell instance $72045 r0 *1 2404.66,5430.7
X$72045 \$18 \$11876 \$17195 VSS INVR02
* cell instance $72048 r0 *1 2437.85,5430.7
X$72048 \$18 \$17286 \$17445 VSS INVR02
* cell instance $72051 r0 *1 2471.16,5430.7
X$72051 \$18 \$16613 \$17286 VSS INVR03
* cell instance $72055 m90 *1 2523.41,5430.7
X$72055 \$18 \$17447 \$17230 VSS INVR03
* cell instance $72057 r0 *1 2528.87,5430.7
X$72057 \$18 \$17449 \$17448 \$17233 VSS AND201
* cell instance $72061 r0 *1 2565.34,5430.7
X$72061 \$17353 \$18 \$17357 \$17451 \$17450 VSS ADNR01
* cell instance $72063 r0 *1 2590.54,5430.7
X$72063 \$18 \$17054 \$17450 VSS INVR02
* cell instance $72069 m90 *1 2680.26,5430.7
X$72069 \$18 \$17065 \$17233 VSS INVR03
* cell instance $72071 m90 *1 2697.66,5430.7
X$72071 \$18 \$17139 \$17357 VSS INVR03
* cell instance $72074 r0 *1 2715.54,5430.7
X$72074 \$18 \$17752 \$17358 VSS INVR03
* cell instance $72078 m90 *1 2761.27,5430.7
X$72078 \$17360 \$17451 \$18 \$17359 VSS OR2101
* cell instance $72087 m90 *1 2830.27,5430.7
X$72087 \$18 \$17244 \$17066 VSS INVR02
* cell instance $72090 m90 *1 2860.27,5430.7
X$72090 \$18 \$16761 \$17058 VSS INVR02
* cell instance $72092 r0 *1 2861.36,5430.7
X$72092 \$18 \$17057 \$17063 VSS INVR02
* cell instance $72098 r0 *1 2921.67,5430.7
X$72098 \$16773 \$17365 \$11737 \$18 VSS NND201
* cell instance $72101 r0 *1 2950.3,5430.7
X$72101 \$11737 \$17460 \$18 \$10061 VSS OR2101
* cell instance $72106 m90 *1 3024.03,5430.7
X$72106 \$17461 \$18 \$17463 \$17460 \$16651 VSS AND301
* cell instance $72111 m90 *1 3084.82,5430.7
X$72111 \$18 \$13621 \$17244 VSS INVR03
* cell instance $72114 m90 *1 3129.44,5430.7
X$72114 \$17464 \$18 \$15994 \$16775 VSS NOR201
* cell instance $72117 m90 *1 3161.96,5430.7
X$72117 \$18 \$12176 \$17371 VSS INVR06
* cell instance $72121 m90 *1 3210.31,5430.7
X$72121 \$17468 \$17466 \$18 \$14125 \$15704 VSS NOR301
* cell instance $72122 m90 *1 3227.11,5430.7
X$72122 \$18 \$17470 \$17469 VSS INVR02
* cell instance $72125 m90 *1 3290.71,5430.7
X$72125 \$17466 \$17071 \$17076 \$15705 \$16650 \$16179 \$18 VSS NOR501
* cell instance $72144 r0 *1 3418.05,5430.7
X$72144 \$18 \$17473 \$16655 VSS INVR02
* cell instance $72319 m90 *1 4849.77,5430.7
X$72319 \$18 \$17474 \$16656 VSS INVR06
* cell instance $72348 r0 *1 5059.78,5430.7
X$72348 \$18 \$17475 \$16216 VSS INVR06
* cell instance $72537 r0 *1 6594.01,5430.7
X$72537 \$18 \$17476 \$16217 VSS INVR06
* cell instance $72538 r0 *1 6623.41,5430.7
X$72538 \$18 \$16217 \$17087 VSS INVR06
* cell instance $72545 m90 *1 6721.45,5430.7
X$72545 \$17477 \$18 \$17250 VSS INVR05
* cell instance $72556 r0 *1 6794.17,5430.7
X$72556 \$18 \$17088 \$17250 VSS INVR03
* cell instance $72817 r0 *1 60.6,5253.3
X$72817 \$18 \$16505 \$16506 VSS INVR02
* cell instance $72819 r0 *1 81,5253.3
X$72819 \$18 \$16068 \$15612 VSS INVR02
* cell instance $72825 r0 *1 123.94,5253.3
X$72825 \$16509 \$18 \$14574 VSS INVR05
* cell instance $72826 r0 *1 149.14,5253.3
X$72826 \$16511 \$18 \$16266 VSS INVR05
* cell instance $72829 r0 *1 180.61,5253.3
X$72829 \$18 \$16403 \$16074 VSS INVR03
* cell instance $72830 r0 *1 197.41,5253.3
X$72830 \$18 \$16506 \$16515 VSS INVR02
* cell instance $72832 m90 *1 243.61,5253.3
X$72832 \$18 \$16516 \$16517 \$16518 VSS AND201
* cell instance $72834 m90 *1 274.21,5253.3
X$72834 \$13549 \$13549 \$18 \$16269 VSS OR2101
* cell instance $72846 r0 *1 380.75,5253.3
X$72846 \$16520 \$15029 \$15473 \$18 VSS NND201
* cell instance $72848 r0 *1 401.75,5253.3
X$72848 \$18 \$14026 \$15033 VSS INVR03
* cell instance $72852 r0 *1 429.94,5253.3
X$72852 \$18 \$16076 \$16521 VSS INVR06
* cell instance $72853 m90 *1 476.14,5253.3
X$72853 \$18 \$15624 \$16523 VSS INVR03
* cell instance $72854 r0 *1 477.04,5253.3
X$72854 \$18 \$16086 \$16266 VSS INVR03
* cell instance $72858 r0 *1 561.63,5253.3
X$72858 \$18 \$16088 \$16473 VSS INVR03
* cell instance $72860 r0 *1 578.43,5253.3
X$72860 \$16465 \$15042 \$13848 \$18 VSS NND201
* cell instance $72862 r0 *1 603.73,5253.3
X$72862 \$18 \$16473 \$16532 VSS INVR03
* cell instance $72863 r0 *1 620.53,5253.3
X$72863 \$16471 \$18 \$16532 VSS INVR01
* cell instance $72865 m90 *1 663.13,5253.3
X$72865 \$18 \$16534 \$16535 \$16527 VSS AND201
* cell instance $72867 r0 *1 665.26,5253.3
X$72867 \$18 \$16537 \$16538 VSS INVR02
* cell instance $72868 r0 *1 682.06,5253.3
X$72868 \$16534 \$16539 \$18 \$16471 VSS OR2101
* cell instance $72869 r0 *1 703.06,5253.3
X$72869 \$18 \$16472 \$15232 VSS INVR03
* cell instance $72871 m90 *1 754.07,5253.3
X$72871 \$18 \$16537 \$15628 \$16473 VSS AND201
* cell instance $72872 r0 *1 754.07,5253.3
X$72872 \$18 \$16538 \$16472 VSS INVR03
* cell instance $72878 r0 *1 808.18,5253.3
X$72878 \$16700 \$16547 \$13852 \$18 VSS NND201
* cell instance $72880 r0 *1 824.98,5253.3
X$72880 \$18 \$16699 \$16548 VSS INVR03
* cell instance $72881 r0 *1 841.78,5253.3
X$72881 \$18 \$16549 \$16550 VSS INVR02
* cell instance $72883 r0 *1 863.13,5253.3
X$72883 \$15232 \$16091 \$18 \$14464 VSS OR2101
* cell instance $72885 m90 *1 930.76,5253.3
X$72885 \$16704 \$16700 \$16554 \$16702 \$16553 \$18 VSS AND401
* cell instance $72887 r0 *1 933.8,5253.3
X$72887 \$16406 \$18 \$16705 VSS INVR05
* cell instance $72890 m90 *1 978.16,5253.3
X$72890 \$18 \$16556 \$16707 VSS INVR02
* cell instance $72905 r0 *1 1087.99,5253.3
X$72905 \$16558 \$18 \$15652 VSS INVR01
* cell instance $72909 r0 *1 1110.77,5253.3
X$72909 \$16558 \$16561 \$18 \$16409 VSS OR2101
* cell instance $72912 r0 *1 1142.51,5253.3
X$72912 \$18 \$15062 \$16562 VSS INVR02
* cell instance $72915 r0 *1 1168.33,5253.3
X$72915 \$18 \$11089 \$16563 VSS INVR06
* cell instance $72919 r0 *1 1221.76,5253.3
X$72919 \$16564 \$18 \$11152 VSS INVR05
* cell instance $72920 r0 *1 1247.57,5253.3
X$72920 \$18 \$16117 \$16112 VSS INVR06
* cell instance $72922 r0 *1 1280.9,5253.3
X$72922 \$16568 \$18 \$16564 VSS INVR01
* cell instance $72926 m90 *1 1316.47,5253.3
X$72926 \$16109 \$16411 \$16561 \$18 VSS NND201
* cell instance $72929 m90 *1 1345.77,5253.3
X$72929 \$16571 \$16062 \$16715 \$18 VSS NND201
* cell instance $72931 m90 *1 1371.8,5253.3
X$72931 \$16411 \$16125 \$16717 \$18 VSS NND201
* cell instance $72934 r0 *1 1376.48,5253.3
X$72934 \$18 \$15652 \$16717 VSS INVR02
* cell instance $72935 r0 *1 1393.28,5253.3
X$72935 \$16721 \$18 \$16119 VSS INVR05
* cell instance $72937 r0 *1 1527.56,5253.3
X$72937 \$18 \$16576 \$16125 VSS INVR02
* cell instance $72938 r0 *1 1544.36,5253.3
X$72938 \$18 \$16725 \$16414 VSS INVR03
* cell instance $72943 r0 *1 1590,5253.3
X$72943 \$18 \$16578 \$15517 VSS INVR02
* cell instance $72944 r0 *1 1606.8,5253.3
X$72944 \$18 \$16416 \$16725 VSS INVR02
* cell instance $72945 r0 *1 1623.61,5253.3
X$72945 \$18 \$14480 \$16130 VSS INVR03
* cell instance $72949 r0 *1 1658.86,5253.3
X$72949 \$18 \$16582 \$16131 VSS INVR06
* cell instance $72952 r0 *1 1702.06,5253.3
X$72952 \$18 \$15075 \$13569 VSS INVR02
* cell instance $72954 m90 *1 1744.06,5253.3
X$72954 \$18 \$16139 \$16133 \$13095 VSS AND201
* cell instance $72957 r0 *1 1754.58,5253.3
X$72957 \$16587 \$18 \$15953 VSS INVR05
* cell instance $72958 r0 *1 1779.78,5253.3
X$72958 \$18 \$16731 \$16729 VSS INVR02
* cell instance $72964 r0 *1 1932.78,5253.3
X$72964 \$16137 \$18 \$15663 \$16145 \$16148 VSS NND301
* cell instance $72966 m90 *1 1987.38,5253.3
X$72966 \$16736 \$14079 \$8585 \$18 VSS NND201
* cell instance $72971 m90 *1 2096.08,5253.3
X$72971 \$13109 \$11888 \$16592 \$15673 \$14078 \$18 VSS AOI401
* cell instance $72973 m90 *1 2125.21,5253.3
X$72973 \$16741 \$15664 \$18 \$11182 VSS OR2101
* cell instance $72977 r0 *1 2150.89,5253.3
X$72977 \$14214 \$16744 \$14213 \$18 \$16742 VSS OR3101
* cell instance $72979 r0 *1 2180.9,5253.3
X$72979 \$18 \$13752 \$16150 VSS INVR06
* cell instance $72981 m90 *1 2234.32,5253.3
X$72981 \$16494 \$16600 \$18 \$15673 VSS OR2101
* cell instance $72983 r0 *1 2234.32,5253.3
X$72983 \$18 \$16600 \$16603 VSS INVR02
* cell instance $72986 m90 *1 2295.23,5253.3
X$72986 \$16494 \$18 \$16302 \$16162 \$14781 VSS AND301
* cell instance $72987 r0 *1 2295.23,5253.3
X$72987 \$18 \$16603 \$14781 VSS INVR02
* cell instance $72989 r0 *1 2316.31,5253.3
X$72989 \$18 \$16158 \$16608 VSS INVR02
* cell instance $72990 m90 *1 2375.11,5253.3
X$72990 \$18 \$16156 \$16164 \$14216 VSS AND201
* cell instance $72994 m90 *1 2457.63,5253.3
X$72994 \$12921 \$16613 \$18 \$16171 VSS OR2101
* cell instance $72996 r0 *1 2467.49,5253.3
X$72996 \$15675 \$11200 \$18 \$13593 VSS OR2101
* cell instance $73008 r0 *1 2581.89,5253.3
X$73008 \$18 \$15137 \$14080 VSS INVR06
* cell instance $73011 r0 *1 2628.75,5253.3
X$73011 \$15675 \$15984 \$18 \$15137 VSS OR2101
* cell instance $73015 r0 *1 2662.96,5253.3
X$73015 \$18 \$15552 \$16625 VSS INVR03
* cell instance $73018 r0 *1 2683.4,5253.3
X$73018 \$15552 \$16627 \$18 \$15137 VSS OR2101
* cell instance $73027 r0 *1 2751.71,5253.3
X$73027 \$18 \$15552 \$15263 VSS INVR02
* cell instance $73031 r0 *1 2778.77,5253.3
X$73031 \$16171 \$16480 \$18 \$16302 VSS OR2101
* cell instance $73034 r0 *1 2805.1,5253.3
X$73034 \$18 \$13446 \$15989 VSS INVR06
* cell instance $73035 m90 *1 2859.7,5253.3
X$73035 \$18 \$13610 \$16187 \$16480 VSS AND201
* cell instance $73037 m90 *1 2894.5,5253.3
X$73037 \$18 \$16171 \$16439 VSS INVR06
* cell instance $73041 r0 *1 2910.8,5253.3
X$73041 \$16639 \$18 \$16197 VSS INVR01
* cell instance $73042 m90 *1 2940.2,5253.3
X$73042 \$18 \$11390 \$16439 VSS INVR03
* cell instance $73045 r0 *1 3031.08,5253.3
X$73045 \$18 \$16642 \$16197 VSS INVR03
* cell instance $73046 m90 *1 3115.09,5253.3
X$73046 \$16773 \$11916 \$15571 \$16199 \$15146 \$16420 \$15268 \$16644 \$18
+ VSS OR7101
* cell instance $73047 r0 *1 3115.09,5253.3
X$73047 \$18 \$15696 \$16775 VSS INVR02
* cell instance $73051 r0 *1 3139.84,5253.3
X$73051 \$18 \$10061 \$16444 VSS INVR06
* cell instance $73052 m90 *1 3186.64,5253.3
X$73052 \$18 \$15994 \$16201 VSS INVR03
* cell instance $73056 m90 *1 3224.06,5253.3
X$73056 \$18 \$16203 \$17074 VSS INVR02
* cell instance $73057 m90 *1 3240.86,5253.3
X$73057 \$18 \$15701 \$16203 VSS INVR03
* cell instance $73058 r0 *1 3240.86,5253.3
X$73058 \$18 \$16650 \$16210 \$13757 VSS AND201
* cell instance $73062 m90 *1 3309.58,5253.3
X$73062 \$18 \$16651 \$16210 VSS INVR06
* cell instance $73065 r0 *1 3316.66,5253.3
X$73065 \$14958 \$11228 \$15576 \$16202 \$16210 \$18 VSS AOI401
* cell instance $73069 r0 *1 3375.58,5253.3
X$73069 \$18 \$13624 \$16653 VSS INVR03
* cell instance $73070 r0 *1 3394.48,5253.3
X$73070 \$18 \$16653 \$16444 VSS INVR03
* cell instance $73074 r0 *1 3424.66,5253.3
X$73074 \$16212 \$15675 \$16655 \$18 VSS NND201
* cell instance $73253 m90 *1 4872.21,5253.3
X$73253 \$18 \$16657 \$16656 VSS INVR03
* cell instance $73258 r0 *1 4886.06,5253.3
X$73258 \$18 \$16213 \$16658 VSS INVR02
* cell instance $73279 r0 *1 5054.33,5253.3
X$73279 \$18 \$15578 \$16215 VSS INVR02
* cell instance $73450 r0 *1 6420.04,5253.3
X$73450 \$18 \$16219 \$16453 VSS INVR03
* cell instance $73456 m90 *1 6575.65,5253.3
X$73456 \$8743 \$14962 \$16453 \$I331485 \$16661 \$18 VSS DFCL11
* cell instance $73464 m90 *1 6651.71,5253.3
X$73464 \$16224 \$16217 \$16223 \$18 VSS XNR201
* cell instance $73468 m90 *1 6687.08,5253.3
X$73468 \$18 \$16665 \$16224 VSS INVR02
* cell instance $73471 m90 *1 6731.68,5253.3
X$73471 \$16665 \$18 \$16225 \$16227 VSS NOR201
* cell instance $73482 m90 *1 6820.81,5253.3
X$73482 \$18 \$16788 \$16225 VSS INVR02
* cell instance $73483 m90 *1 6837.61,5253.3
X$73483 \$18 \$16789 \$16788 VSS INVR02
* cell instance $73485 m90 *1 6863.3,5253.3
X$73485 \$16670 \$16789 \$18 \$16228 VSS OR2101
* cell instance $73488 m90 *1 6893.8,5253.3
X$73488 \$16670 \$18 \$16671 VSS INVR01
* cell instance $73518 r0 *1 7118.36,5253.3
X$73518 \$18 \$16227 \$15597 VSS INVR03
* cell instance $73739 r0 *1 207.01,3834.1
X$73739 \$18 \$7760 \$7248 VSS INVR03
* cell instance $73740 r0 *1 223.81,3834.1
X$73740 \$18 \$7391 \$7762 VSS INVR03
* cell instance $73742 r0 *1 243.44,3834.1
X$73742 \$7329 \$18 \$7859 \$8121 VSS NOR201
* cell instance $73743 m90 *1 293.84,3834.1
X$73743 \$18 \$8122 \$7859 VSS INVR03
* cell instance $73746 r0 *1 310.44,3834.1
X$73746 \$18 \$7479 \$7123 VSS INVR02
* cell instance $73747 m90 *1 352.44,3834.1
X$73747 \$18 \$7857 \$7254 \$7761 VSS AND201
* cell instance $73749 m90 *1 388.23,3834.1
X$73749 \$7482 \$18 \$7614 \$7131 VSS NOR201
* cell instance $73750 m90 *1 405.04,3834.1
X$73750 \$7866 \$7686 \$7489 \$18 VSS NND201
* cell instance $73753 r0 *1 418.24,3834.1
X$73753 \$18 \$8132 \$7780 \$7489 VSS AND201
* cell instance $73765 m90 *1 547.22,3834.1
X$73765 \$8133 \$18 \$7131 \$7614 VSS NOR201
* cell instance $73767 m90 *1 583.05,3834.1
X$73767 \$8135 \$18 \$7131 \$8008 VSS NOR201
* cell instance $73772 m90 *1 633.49,3834.1
X$73772 \$8008 \$8137 \$18 \$7779 VSS OR2101
* cell instance $73776 r0 *1 645.22,3834.1
X$73776 \$18 \$7614 \$8230 VSS INVR02
* cell instance $73778 r0 *1 662.02,3834.1
X$73778 \$18 \$8230 \$8008 VSS INVR02
* cell instance $73780 m90 *1 697.74,3834.1
X$73780 \$18 \$7499 \$7778 VSS INVR02
* cell instance $73781 m90 *1 714.54,3834.1
X$73781 \$18 \$8141 \$7872 VSS INVR02
* cell instance $73782 r0 *1 714.54,3834.1
X$73782 \$18 \$6334 \$8011 VSS INVR06
* cell instance $73785 m90 *1 772.33,3834.1
X$73785 \$18 \$5999 \$8141 VSS INVR02
* cell instance $73788 r0 *1 774.94,3834.1
X$73788 \$18 \$8365 \$8143 VSS INVR02
* cell instance $73797 r0 *1 846.17,3834.1
X$73797 \$8144 \$18 \$6249 VSS INVR01
* cell instance $73801 m90 *1 898.74,3834.1
X$73801 \$7500 \$18 \$8145 \$8320 \$8147 VSS ADNR01
* cell instance $73803 m90 *1 928.75,3834.1
X$73803 \$8151 \$7876 \$18 \$6872 VSS OR2101
* cell instance $73804 m90 *1 946.6,3834.1
X$73804 \$18 \$8150 \$8145 VSS INVR02
* cell instance $73808 m90 *1 988.75,3834.1
X$73808 \$18 \$8151 \$7587 \$7139 VSS AND201
* cell instance $73811 r0 *1 1001.95,3834.1
X$73811 \$18 \$7878 \$8154 VSS INVR03
* cell instance $73818 r0 *1 1049.82,3834.1
X$73818 \$8147 \$18 \$8155 VSS INVR05
* cell instance $73821 r0 *1 1078.75,3834.1
X$73821 \$18 \$8157 \$8015 VSS INVR02
* cell instance $73826 m90 *1 1238.09,3834.1
X$73826 \$7523 \$7511 \$18 \$7793 VSS OR2101
* cell instance $73829 r0 *1 1255.38,3834.1
X$73829 \$8260 \$18 \$8257 \$6880 \$8161 VSS NND301
* cell instance $73835 r0 *1 1315.84,3834.1
X$73835 \$18 \$8260 \$8162 VSS INVR02
* cell instance $73837 r0 *1 1333.68,3834.1
X$73837 \$18 \$7901 \$8261 VSS INVR06
* cell instance $73838 r0 *1 1363.08,3834.1
X$73838 \$18 \$7423 \$7278 \$7608 VSS AND201
* cell instance $73839 m90 *1 1405.08,3834.1
X$73839 \$18 \$8024 \$7608 VSS INVR02
* cell instance $73842 r0 *1 1415.41,3834.1
X$73842 \$18 \$8023 \$8263 \$7888 VSS AND201
* cell instance $73843 r0 *1 1440.61,3834.1
X$73843 \$18 \$5255 \$8166 VSS INVR06
* cell instance $73844 r0 *1 1470.01,3834.1
X$73844 \$7894 \$8264 \$18 \$8327 VSS OR2101
* cell instance $73845 r0 *1 1491.01,3834.1
X$73845 \$8263 \$7804 \$7159 \$18 VSS NND201
* cell instance $73846 m90 *1 1533.01,3834.1
X$73846 \$18 \$8169 \$5255 \$6806 VSS AND201
* cell instance $73849 r0 *1 1539.3,3834.1
X$73849 \$18 \$7172 \$7060 VSS INVR02
* cell instance $73851 r0 *1 1561.42,3834.1
X$73851 \$18 \$8170 \$8171 VSS INVR03
* cell instance $73854 r0 *1 1583.4,3834.1
X$73854 \$7526 \$18 \$6870 VSS INVR01
* cell instance $73857 m90 *1 1621.42,3834.1
X$73857 \$18 \$8172 \$7709 VSS INVR03
* cell instance $73858 m90 *1 1650.82,3834.1
X$73858 \$8023 \$7810 \$7809 \$18 \$8174 VSS OR3101
* cell instance $73859 r0 *1 1650.82,3834.1
X$73859 \$18 \$8176 \$8029 VSS INVR06
* cell instance $73862 r0 *1 1690.33,3834.1
X$73862 \$18 \$6279 \$7900 VSS INVR06
* cell instance $73863 r0 *1 1719.73,3834.1
X$73863 \$18 \$6282 \$8172 VSS INVR02
* cell instance $73873 r0 *1 2088.31,3834.1
X$73873 \$18 \$8183 \$8182 \$7907 VSS AND201
* cell instance $73874 r0 *1 2113.51,3834.1
X$73874 \$8182 \$18 \$8036 \$8184 \$8185 VSS AND301
* cell instance $73877 r0 *1 2157.16,3834.1
X$73877 \$18 \$8187 \$7186 VSS INVR06
* cell instance $73878 m90 *1 2203.36,3834.1
X$73878 \$18 \$8189 \$7821 VSS INVR02
* cell instance $73881 r0 *1 2211.26,3834.1
X$73881 \$18 \$8193 \$7907 \$8192 VSS AND201
* cell instance $73883 r0 *1 2236.46,3834.1
X$73883 \$18 \$8193 \$8194 VSS INVR02
* cell instance $73885 r0 *1 2259.27,3834.1
X$73885 \$18 \$8194 \$7930 VSS INVR03
* cell instance $73889 r0 *1 2292.87,3834.1
X$73889 \$18 \$6748 \$7913 VSS INVR02
* cell instance $73890 r0 *1 2309.67,3834.1
X$73890 \$18 \$6748 \$7925 VSS INVR03
* cell instance $73891 r0 *1 2326.47,3834.1
X$73891 \$18 \$8271 \$8198 VSS INVR02
* cell instance $73892 r0 *1 2344.39,3834.1
X$73892 \$8029 \$18 \$8198 VSS INVR05
* cell instance $73894 r0 *1 2369.59,3834.1
X$73894 \$7562 \$18 \$7924 VSS INVR05
* cell instance $73895 m90 *1 2512.4,3834.1
X$73895 \$18 \$8274 \$8202 VSS INVR03
* cell instance $73899 r0 *1 2528.05,3834.1
X$73899 \$7567 \$7571 \$18 \$7933 VSS OR2101
* cell instance $73903 r0 *1 2561.81,3834.1
X$73903 \$18 \$8049 \$7901 VSS INVR06
* cell instance $73904 r0 *1 2591.21,3834.1
X$73904 \$18 \$7931 \$7934 VSS INVR03
* cell instance $73907 r0 *1 2615.68,3834.1
X$73907 \$18 \$7569 \$7834 VSS INVR02
* cell instance $73909 r0 *1 2633.4,3834.1
X$73909 \$18 \$7572 \$7936 VSS INVR06
* cell instance $73911 r0 *1 2672.26,3834.1
X$73911 \$18 \$6748 \$8205 VSS INVR03
* cell instance $73915 r0 *1 2706.39,3834.1
X$73915 \$18 \$7938 \$8206 VSS INVR03
* cell instance $73919 m90 *1 2752.69,3834.1
X$73919 \$18 \$7624 \$7836 VSS INVR02
* cell instance $73922 m90 *1 2795.72,3834.1
X$73922 \$18 \$7624 \$8210 VSS INVR06
* cell instance $73925 m90 *1 2818.47,3834.1
X$73925 \$18 \$8211 \$8210 VSS INVR03
* cell instance $73931 r0 *1 2852.45,3834.1
X$73931 \$18 \$7843 \$8229 VSS INVR03
* cell instance $73933 r0 *1 2869.25,3834.1
X$73933 \$8212 \$18 \$8229 VSS INVR05
* cell instance $73947 m90 *1 3015.27,3834.1
X$73947 \$18 \$8214 \$8213 VSS INVR03
* cell instance $73953 m90 *1 3076.63,3834.1
X$73953 \$18 \$8215 \$8216 VSS INVR06
* cell instance $73961 m90 *1 3145.03,3834.1
X$73961 \$18 \$8216 \$8225 VSS INVR06
* cell instance $73963 m90 *1 3161.84,3834.1
X$73963 \$18 \$8218 \$8225 VSS INVR03
* cell instance $74045 r0 *1 3793.47,3834.1
X$74045 \$18 \$8057 \$8049 VSS INVR06
* cell instance $74197 r0 *1 5014.16,3834.1
X$74197 \$18 \$8058 \$8057 VSS INVR06
* cell instance $74680 r0 *1 83.6,3124.5
X$74680 \$18 \$5387 \$5720 VSS INVR02
* cell instance $74681 m90 *1 138.2,3124.5
X$74681 \$5581 \$5637 \$18 \$5836 \$4876 VSS NOR301
* cell instance $74683 r0 *1 147.2,3124.5
X$74683 \$4876 \$5110 \$18 \$5581 VSS OR2101
* cell instance $74686 r0 *1 177.43,3124.5
X$74686 \$5643 \$18 \$5394 VSS INVR05
* cell instance $74688 m90 *1 240.43,3124.5
X$74688 \$5517 \$5585 \$5724 \$18 VSS XNR201
* cell instance $74689 r0 *1 240.43,3124.5
X$74689 \$18 \$5585 \$5584 VSS INVR02
* cell instance $74690 r0 *1 257.23,3124.5
X$74690 \$18 \$5585 \$5841 VSS INVR02
* cell instance $74691 r0 *1 274.03,3124.5
X$74691 \$18 \$5393 \$5386 \$5020 VSS AND201
* cell instance $74693 r0 *1 307.7,3124.5
X$74693 \$18 \$5728 \$5643 VSS INVR06
* cell instance $74694 r0 *1 337.63,3124.5
X$74694 \$5644 \$5123 \$18 \$5581 VSS OR2101
* cell instance $74698 r0 *1 374.41,3124.5
X$74698 \$18 \$5519 \$5412 VSS INVR02
* cell instance $74702 m90 *1 414.43,3124.5
X$74702 \$18 \$5389 \$5585 VSS INVR03
* cell instance $74707 r0 *1 440.83,3124.5
X$74707 \$18 \$5729 \$5395 VSS INVR02
* cell instance $74710 r0 *1 460.78,3124.5
X$74710 \$18 \$5730 \$5617 VSS INVR06
* cell instance $74712 r0 *1 499.84,3124.5
X$74712 \$5652 \$5319 \$5844 \$18 VSS XNR201
* cell instance $74716 r0 *1 555.19,3124.5
X$74716 \$5397 \$5589 \$5657 \$18 VSS XNR201
* cell instance $74718 r0 *1 592.99,3124.5
X$74718 \$18 \$5735 \$5402 VSS INVR02
* cell instance $74719 r0 *1 609.79,3124.5
X$74719 \$18 \$5403 \$5397 VSS INVR02
* cell instance $74720 r0 *1 626.59,3124.5
X$74720 \$18 \$5737 \$5617 VSS INVR03
* cell instance $74722 m90 *1 670.71,3124.5
X$74722 \$18 \$5738 \$3856 \$5657 VSS AND201
* cell instance $74725 r0 *1 678.46,3124.5
X$74725 \$18 \$5592 \$5407 VSS INVR03
* cell instance $74729 r0 *1 707.87,3124.5
X$74729 \$18 \$3064 \$5659 VSS INVR06
* cell instance $74734 r0 *1 759.16,3124.5
X$74734 \$18 \$5392 \$5624 VSS INVR06
* cell instance $74735 r0 *1 790.42,3124.5
X$74735 \$18 \$5739 \$5663 VSS INVR03
* cell instance $74737 r0 *1 807.22,3124.5
X$74737 \$18 \$5740 \$5739 VSS INVR02
* cell instance $74738 r0 *1 824.02,3124.5
X$74738 \$18 \$5664 \$5663 VSS INVR06
* cell instance $74739 r0 *1 853.42,3124.5
X$74739 \$18 \$5664 \$5592 VSS INVR03
* cell instance $74742 r0 *1 882.81,3124.5
X$74742 \$5413 \$5524 \$5411 \$18 VSS NND201
* cell instance $74743 r0 *1 901.57,3124.5
X$74743 \$18 \$5664 \$4744 VSS INVR03
* cell instance $74750 m90 *1 971.27,3124.5
X$74750 \$18 \$3227 \$5415 VSS INVR03
* cell instance $74753 r0 *1 983.75,3124.5
X$74753 \$18 \$5744 \$5624 VSS INVR03
* cell instance $74757 m90 *1 1041.75,3124.5
X$74757 \$5524 \$5133 \$18 \$5673 VSS OR2101
* cell instance $74767 m90 *1 1138.04,3124.5
X$74767 \$5418 \$18 \$5415 \$5420 VSS NOR201
* cell instance $74772 m90 *1 1188.43,3124.5
X$74772 \$18 \$5676 \$5747 VSS INVR02
* cell instance $74776 r0 *1 1199.43,3124.5
X$74776 \$5421 \$18 \$5414 \$5678 VSS NOR201
* cell instance $74779 r0 *1 1236.01,3124.5
X$74779 \$5681 \$5141 \$5428 \$18 VSS XNR201
* cell instance $74781 m90 *1 1295.07,3124.5
X$74781 \$18 \$5750 \$5681 VSS INVR03
* cell instance $74787 m90 *1 1393.29,3124.5
X$74787 \$18 \$5754 \$5053 \$5433 VSS AND201
* cell instance $74789 r0 *1 1395.67,3124.5
X$74789 \$18 \$5683 \$5751 VSS INVR02
* cell instance $74791 r0 *1 1414.58,3124.5
X$74791 \$18 \$5053 \$5438 VSS INVR02
* cell instance $74792 m90 *1 1448.18,3124.5
X$74792 \$18 \$5430 \$5433 VSS INVR03
* cell instance $74793 r0 *1 1448.18,3124.5
X$74793 \$18 \$5335 \$5683 VSS INVR02
* cell instance $74794 r0 *1 1465.48,3124.5
X$74794 \$18 \$5740 \$5686 VSS INVR06
* cell instance $74795 r0 *1 1494.88,3124.5
X$74795 \$5147 \$5443 \$18 \$5339 VSS OR2101
* cell instance $74796 r0 *1 1517.64,3124.5
X$74796 \$18 \$5689 \$5626 VSS INVR03
* cell instance $74798 r0 *1 1534.44,3124.5
X$74798 \$18 \$5740 \$5689 VSS INVR02
* cell instance $74799 r0 *1 1551.24,3124.5
X$74799 \$18 \$5118 \$5693 VSS INVR06
* cell instance $74800 r0 *1 1580.64,3124.5
X$74800 \$18 \$5447 \$5764 VSS INVR03
* cell instance $74801 r0 *1 1597.44,3124.5
X$74801 \$18 \$5693 \$5626 VSS INVR06
* cell instance $74804 r0 *1 1639.44,3124.5
X$74804 \$5338 \$5620 \$5446 \$18 VSS NND201
* cell instance $74805 r0 *1 1656.24,3124.5
X$74805 \$5620 \$18 \$5447 \$4987 \$5697 VSS AND301
* cell instance $74806 m90 *1 1702.44,3124.5
X$74806 \$5857 \$18 \$5699 VSS INVR01
* cell instance $74809 r0 *1 1760.03,3124.5
X$74809 \$18 \$5771 \$5454 VSS INVR02
* cell instance $74811 r0 *1 1778.19,3124.5
X$74811 \$4822 \$5771 \$18 \$5158 VSS OR2101
* cell instance $74816 r0 *1 1911.72,3124.5
X$74816 \$18 \$3654 \$5774 VSS INVR02
* cell instance $74817 r0 *1 1928.52,3124.5
X$74817 \$18 \$3655 \$5703 VSS INVR03
* cell instance $74820 r0 *1 1955.52,3124.5
X$74820 \$18 \$5346 \$3243 VSS INVR03
* cell instance $74825 r0 *1 1995.71,3124.5
X$74825 \$3979 \$18 \$5704 VSS INVR05
* cell instance $74829 m90 *1 2050.43,3124.5
X$74829 \$18 \$5703 \$5775 VSS INVR03
* cell instance $74832 m90 *1 2073.9,3124.5
X$74832 \$18 \$4915 \$5778 VSS INVR02
* cell instance $74835 r0 *1 2086.35,3124.5
X$74835 \$18 \$5779 \$5705 VSS INVR03
* cell instance $74841 r0 *1 2134.27,3124.5
X$74841 \$18 \$5462 \$5463 VSS INVR02
* cell instance $74846 r0 *1 2336.14,3124.5
X$74846 \$18 \$5478 \$2835 \$5477 VSS AND201
* cell instance $74849 r0 *1 2372.64,3124.5
X$74849 \$18 \$4161 \$5090 VSS INVR02
* cell instance $75065 r0 *1 4090.82,3124.5
X$75065 \$18 \$5790 \$5710 VSS INVR06
* cell instance $75066 r0 *1 4120.22,3124.5
X$75066 \$18 \$5791 \$5711 VSS INVR06
* cell instance $75096 r0 *1 4372.82,3124.5
X$75096 \$18 \$5793 \$5712 VSS INVR03
* cell instance $75100 r0 *1 4399.52,3124.5
X$75100 \$18 \$2789 \$5712 VSS INVR06
* cell instance $75321 r0 *1 6223.02,3124.5
X$75321 \$5795 \$18 \$3834 VSS INVR05
* cell instance $75653 r0 *1 45.12,2592.3
X$75653 \$18 \$3209 \$4079 VSS INVR03
* cell instance $75661 r0 *1 114.52,2592.3
X$75661 \$18 \$4079 \$4022 VSS INVR02
* cell instance $75662 m90 *1 153.89,2592.3
X$75662 \$4081 \$3810 \$18 \$4079 VSS OR2101
* cell instance $75664 r0 *1 153.89,2592.3
X$75664 \$4082 \$4022 \$4181 \$18 VSS NND201
* cell instance $75667 r0 *1 183.89,2592.3
X$75667 \$4051 \$4022 \$3961 \$18 VSS NND201
* cell instance $75671 r0 *1 213.89,2592.3
X$75671 \$18 \$3857 \$3860 VSS INVR02
* cell instance $75673 m90 *1 247.49,2592.3
X$75673 \$18 \$3862 \$3961 VSS INVR02
* cell instance $75676 r0 *1 261.39,2592.3
X$75676 \$4081 \$3710 \$18 \$4051 VSS OR2101
* cell instance $75678 r0 *1 282.39,2592.3
X$75678 \$18 \$3865 \$3707 VSS INVR03
* cell instance $75679 r0 *1 299.19,2592.3
X$75679 \$18 \$4087 \$4088 VSS INVR02
* cell instance $75683 r0 *1 417.26,2592.3
X$75683 \$18 \$4091 \$3814 VSS INVR03
* cell instance $75685 r0 *1 442.47,2592.3
X$75685 \$18 \$3866 \$4094 VSS INVR02
* cell instance $75686 r0 *1 459.87,2592.3
X$75686 \$4096 \$18 \$3882 VSS INVR01
* cell instance $75687 r0 *1 472.47,2592.3
X$75687 \$18 \$4295 \$4097 VSS INVR02
* cell instance $75688 r0 *1 489.27,2592.3
X$75688 \$18 \$4094 \$3615 VSS INVR03
* cell instance $75694 r0 *1 612.47,2592.3
X$75694 \$18 \$4101 \$4102 VSS INVR02
* cell instance $75700 m90 *1 677.14,2592.3
X$75700 \$18 \$4027 \$4103 VSS INVR03
* cell instance $75703 r0 *1 685.38,2592.3
X$75703 \$18 \$4100 \$4027 VSS INVR03
* cell instance $75705 r0 *1 711.08,2592.3
X$75705 \$18 \$4027 \$3713 VSS INVR02
* cell instance $75707 m90 *1 749.57,2592.3
X$75707 \$18 \$4107 \$4105 VSS INVR02
* cell instance $75710 r0 *1 762.07,2592.3
X$75710 \$18 \$3064 \$4107 VSS INVR02
* cell instance $75712 r0 *1 787.1,2592.3
X$75712 \$18 \$4107 \$4201 VSS INVR02
* cell instance $75717 m90 *1 864.12,2592.3
X$75717 \$3628 \$3569 \$3715 \$18 VSS XNR201
* cell instance $75719 m90 *1 897.69,2592.3
X$75719 \$18 \$3629 \$4110 VSS INVR06
* cell instance $75721 r0 *1 900.67,2592.3
X$75721 \$18 \$3886 \$4112 VSS INVR02
* cell instance $75725 r0 *1 930.96,2592.3
X$75725 \$18 \$3969 \$4113 VSS INVR06
* cell instance $75731 r0 *1 1063.62,2592.3
X$75731 \$4030 \$3724 \$3885 \$18 VSS XNR201
* cell instance $75735 r0 *1 1191.15,2592.3
X$75735 \$18 \$4118 \$4119 VSS INVR02
* cell instance $75761 r0 *1 1491.01,2592.3
X$75761 \$18 \$4121 \$4122 VSS INVR02
* cell instance $75764 m90 *1 1535.25,2592.3
X$75764 \$18 \$3894 \$3359 VSS INVR03
* cell instance $75766 m90 *1 1576.64,2592.3
X$75766 \$3893 \$4124 \$4123 \$18 VSS XNR201
* cell instance $75773 r0 *1 1618.28,2592.3
X$75773 \$3897 \$4124 \$3896 \$3232 \$4126 \$18 VSS AND401
* cell instance $75779 r0 *1 1682.79,2592.3
X$75779 \$18 \$3898 \$4128 VSS INVR02
* cell instance $75783 r0 *1 1714.83,2592.3
X$75783 \$18 \$4128 \$4077 VSS INVR03
* cell instance $75785 m90 *1 1773.64,2592.3
X$75785 \$4132 \$3906 \$3232 \$4077 \$4130 \$4212 \$18 VSS AND501
* cell instance $75786 r0 *1 1773.64,2592.3
X$75786 \$18 \$4134 \$4135 VSS INVR03
* cell instance $75788 r0 *1 1793.61,2592.3
X$75788 \$18 \$4136 \$4137 VSS INVR02
* cell instance $75795 m90 *1 1870.37,2592.3
X$75795 \$18 \$4136 \$2835 \$4139 VSS AND201
* cell instance $75801 r0 *1 1901.5,2592.3
X$75801 \$4039 \$18 \$4215 VSS INVR01
* cell instance $75806 r0 *1 1933.44,2592.3
X$75806 \$3902 \$18 \$3904 VSS INVR05
* cell instance $75810 r0 *1 1964.85,2592.3
X$75810 \$3916 \$18 \$4071 VSS INVR05
* cell instance $75814 r0 *1 2008.33,2592.3
X$75814 \$18 \$3902 \$4040 VSS INVR02
* cell instance $75817 r0 *1 2041.71,2592.3
X$75817 \$18 \$4146 \$4071 VSS INVR02
* cell instance $75818 r0 *1 2058.52,2592.3
X$75818 \$18 \$3910 \$4148 VSS INVR03
* cell instance $75819 r0 *1 2075.32,2592.3
X$75819 \$18 \$4148 \$3981 VSS INVR03
* cell instance $75820 m90 *1 2117.33,2592.3
X$75820 \$18 \$3909 \$2835 \$3911 VSS AND201
* cell instance $75822 r0 *1 2122.13,2592.3
X$75822 \$18 \$3914 \$3657 VSS INVR02
* cell instance $75825 m90 *1 2168.93,2592.3
X$75825 \$18 \$3247 \$4155 VSS INVR02
* cell instance $75829 r0 *1 2182.13,2592.3
X$75829 \$18 \$3916 \$4175 VSS INVR03
* cell instance $75831 r0 *1 2198.93,2592.3
X$75831 \$18 \$4060 \$4175 VSS INVR06
* cell instance $75834 m90 *1 2259.06,2592.3
X$75834 \$4157 \$3917 \$4371 \$18 VSS NND201
* cell instance $75837 r0 *1 2264.67,2592.3
X$75837 \$18 \$3659 \$3918 VSS INVR03
* cell instance $75844 r0 *1 2322.39,2592.3
X$75844 \$18 \$4161 \$3981 VSS INVR06
* cell instance $75845 r0 *1 2351.79,2592.3
X$75845 \$18 \$2992 \$4060 VSS INVR06
* cell instance $75850 m90 *1 2427.59,2592.3
X$75850 \$18 \$2992 \$3926 VSS INVR02
* cell instance $75854 r0 *1 2434.29,2592.3
X$75854 \$18 \$3918 \$4047 VSS INVR02
* cell instance $75857 r0 *1 2457.6,2592.3
X$75857 \$4166 \$4047 \$3924 \$18 VSS NND201
* cell instance $75861 r0 *1 2481.46,2592.3
X$75861 \$4167 \$18 \$3932 \$4166 VSS NOR201
* cell instance $75865 r0 *1 2529.58,2592.3
X$75865 \$18 \$4167 \$4168 VSS INVR03
* cell instance $76096 r0 *1 4377.16,2592.3
X$76096 \$18 \$3937 \$3677 VSS INVR02
* cell instance $76110 r0 *1 4493.36,2592.3
X$76110 \$18 \$4169 \$4170 VSS INVR03
* cell instance $76117 r0 *1 4543.49,2592.3
X$76117 \$18 \$2816 \$4170 VSS INVR06
* cell instance $76141 r0 *1 4753.27,2592.3
X$76141 \$18 \$3760 \$3946 VSS INVR02
* cell instance $76178 r0 *1 5053.42,2592.3
X$76178 \$18 \$4221 \$3695 VSS INVR02
* cell instance $76661 r0 *1 394.2,2414.9
X$76661 \$18 \$3611 \$3566 VSS INVR02
* cell instance $76665 m90 *1 464.2,2414.9
X$76665 \$3710 \$3614 \$3613 \$18 VSS XNR201
* cell instance $76667 r0 *1 464.2,2414.9
X$76667 \$18 \$3615 \$3616 VSS INVR03
* cell instance $76670 r0 *1 488.88,2414.9
X$76670 \$18 \$3566 \$3618 VSS INVR03
* cell instance $76675 r0 *1 524.21,2414.9
X$76675 \$18 \$3394 \$3620 VSS INVR03
* cell instance $76678 r0 *1 554.21,2414.9
X$76678 \$18 \$3395 \$3774 VSS INVR02
* cell instance $76680 r0 *1 571.01,2414.9
X$76680 \$18 \$3774 \$3348 VSS INVR03
* cell instance $76690 m90 *1 733.72,2414.9
X$76690 \$3713 \$3594 \$3397 \$18 VSS XNR201
* cell instance $76693 m90 *1 767.1,2414.9
X$76693 \$18 \$3403 \$3594 VSS INVR02
* cell instance $76696 m90 *1 804.52,2414.9
X$76696 \$18 \$3626 \$3215 \$3715 VSS AND201
* cell instance $76699 m90 *1 850.6,2414.9
X$76699 \$3628 \$18 \$3136 \$3506 VSS NOR201
* cell instance $76701 m90 *1 876.77,2414.9
X$76701 \$18 \$3225 \$3506 VSS INVR03
* cell instance $76705 r0 *1 893.57,2414.9
X$76705 \$3635 \$3629 \$3406 \$18 VSS XNR201
* cell instance $76708 r0 *1 934.59,2414.9
X$76708 \$18 \$3718 \$3631 VSS INVR06
* cell instance $76709 r0 *1 965.74,2414.9
X$76709 \$18 \$3632 \$3404 VSS INVR02
* cell instance $76713 r0 *1 998.59,2414.9
X$76713 \$18 \$3634 \$3635 VSS INVR02
* cell instance $76717 r0 *1 1030.78,2414.9
X$76717 \$18 \$3570 \$3723 VSS INVR03
* cell instance $76719 r0 *1 1047.58,2414.9
X$76719 \$18 \$3788 \$3724 VSS INVR02
* cell instance $76728 r0 *1 1122.73,2414.9
X$76728 \$18 \$3636 \$3637 VSS INVR03
* cell instance $76761 r0 *1 1392.58,2414.9
X$76761 \$18 \$3638 \$3639 VSS INVR02
* cell instance $76765 r0 *1 1420.29,2414.9
X$76765 \$3640 \$18 \$3356 VSS INVR05
* cell instance $76770 r0 *1 1472.06,2414.9
X$76770 \$18 \$3233 \$3641 VSS INVR04
* cell instance $76771 m90 *1 1518.49,2414.9
X$76771 \$18 \$3410 \$2835 \$3358 VSS AND201
* cell instance $76774 r0 *1 1523.67,2414.9
X$76774 \$18 \$3392 \$3411 VSS INVR06
* cell instance $76781 r0 *1 1601.63,2414.9
X$76781 \$3414 \$3727 \$3728 \$3232 \$3645 \$18 VSS AND401
* cell instance $76785 r0 *1 1659.06,2414.9
X$76785 \$18 \$3645 \$3730 VSS INVR02
* cell instance $76787 r0 *1 1676.62,2414.9
X$76787 \$3647 \$18 \$3646 VSS INVR05
* cell instance $76796 r0 *1 1760.49,2414.9
X$76796 \$18 \$3549 \$3422 VSS INVR02
* cell instance $76797 r0 *1 1777.29,2414.9
X$76797 \$18 \$3549 \$2835 \$3421 VSS AND201
* cell instance $76801 r0 *1 1828.39,2414.9
X$76801 \$3236 \$3735 \$18 \$3239 \$3517 VSS NOR301
* cell instance $76803 m90 *1 1889.18,2414.9
X$76803 \$3573 \$3517 \$18 \$3653 VSS OR2101
* cell instance $76807 r0 *1 1905.45,2414.9
X$76807 \$18 \$3737 \$3654 VSS INVR03
* cell instance $76808 r0 *1 1922.25,2414.9
X$76808 \$18 \$3738 \$3655 VSS INVR03
* cell instance $76809 r0 *1 2123.85,2414.9
X$76809 \$18 \$3248 \$3657 VSS INVR04
* cell instance $76810 r0 *1 2145.41,2414.9
X$76810 \$18 \$3519 \$3802 VSS INVR02
* cell instance $76811 r0 *1 2162.21,2414.9
X$76811 \$18 \$3802 \$3659 VSS INVR03
* cell instance $76819 m90 *1 2243.94,2414.9
X$76819 \$18 \$3660 \$2835 \$3662 VSS AND201
* cell instance $76820 r0 *1 2243.94,2414.9
X$76820 \$18 \$3660 \$3664 VSS INVR03
* cell instance $76823 r0 *1 2273.71,2414.9
X$76823 \$18 \$3665 \$3432 VSS INVR02
* cell instance $76825 r0 *1 2293.68,2414.9
X$76825 \$18 \$3433 \$3436 VSS INVR03
* cell instance $76834 m90 *1 2406.19,2414.9
X$76834 \$3747 \$3435 \$3254 \$18 VSS XNR201
* cell instance $76837 r0 *1 2415.93,2414.9
X$76837 \$3602 \$2992 \$3435 \$18 VSS NND201
* cell instance $76841 m90 *1 2481.46,2414.9
X$76841 \$3748 \$3436 \$3252 \$18 VSS XNR201
* cell instance $76845 r0 *1 2496.11,2414.9
X$76845 \$18 \$3602 \$3830 VSS INVR02
* cell instance $77049 r0 *1 4132.42,2414.9
X$77049 \$18 \$3528 \$3673 VSS INVR03
* cell instance $77066 r0 *1 4263.86,2414.9
X$77066 \$18 \$3172 \$3528 VSS INVR03
* cell instance $77076 m90 *1 4366.91,2414.9
X$77076 \$18 \$3675 \$3439 VSS INVR03
* cell instance $77080 m90 *1 4395.26,2414.9
X$77080 \$18 \$3445 \$3176 VSS INVR03
* cell instance $77084 r0 *1 4403.11,2414.9
X$77084 \$18 \$3677 \$3445 VSS INVR03
* cell instance $77087 r0 *1 4428.08,2414.9
X$77087 \$18 \$3752 \$3596 VSS INVR02
* cell instance $77088 m90 *1 4465.88,2414.9
X$77088 \$3579 \$3374 \$18 \$2905 VSS OR2101
* cell instance $77091 r0 *1 4483.16,2414.9
X$77091 \$18 \$3596 \$3016 VSS INVR03
* cell instance $77093 m90 *1 4521.98,2414.9
X$77093 \$3452 \$3579 \$18 \$3448 VSS OR2101
* cell instance $77096 r0 *1 4527.61,2414.9
X$77096 \$18 \$3016 \$3682 VSS INVR02
* cell instance $77099 m90 *1 4564.83,2414.9
X$77099 \$18 \$3590 \$3452 VSS INVR02
* cell instance $77102 r0 *1 4568.26,2414.9
X$77102 \$2859 \$3684 \$18 \$2432 \$3452 VSS NOR301
* cell instance $77105 m90 *1 4632.52,2414.9
X$77105 \$18 \$3583 \$2432 \$3456 VSS AND201
* cell instance $77107 m90 *1 4671.77,2414.9
X$77107 \$3590 \$18 \$3090 \$3468 VSS NOR201
* cell instance $77111 m90 *1 4695.82,2414.9
X$77111 \$18 \$3468 \$3460 VSS INVR03
* cell instance $77120 r0 *1 4746.73,2414.9
X$77120 \$18 \$3465 \$3460 \$3459 VSS AND201
* cell instance $77121 r0 *1 4771.94,2414.9
X$77121 \$18 \$3181 \$3760 VSS INVR02
* cell instance $77122 r0 *1 4788.81,2414.9
X$77122 \$18 \$2867 \$3691 VSS INVR03
* cell instance $77126 r0 *1 4830.98,2414.9
X$77126 \$3082 \$18 \$3098 VSS INVR05
* cell instance $77134 r0 *1 4905.72,2414.9
X$77134 \$18 \$3189 \$3472 VSS INVR03
* cell instance $77136 r0 *1 4922.52,2414.9
X$77136 \$2501 \$18 \$3473 VSS INVR05
* cell instance $77151 r0 *1 5050.93,2414.9
X$77151 \$18 \$3695 \$3696 VSS INVR03
* cell instance $77632 r0 *1 68.72,2237.5
X$77632 \$18 \$3208 \$3063 VSS INVR06
* cell instance $77640 m90 *1 165.23,2237.5
X$77640 \$18 \$2894 \$3063 VSS INVR03
* cell instance $77658 r0 *1 291.53,2237.5
X$77658 \$18 \$3133 \$3210 VSS INVR02
* cell instance $77669 r0 *1 386.4,2237.5
X$77669 \$18 \$3211 \$3209 VSS INVR03
* cell instance $77702 m90 *1 753.42,2237.5
X$77702 \$18 \$3213 \$3215 \$3134 VSS AND201
* cell instance $77705 m90 *1 798.98,2237.5
X$77705 \$3136 \$2972 \$3134 \$18 VSS XNR201
* cell instance $77707 m90 *1 838.78,2237.5
X$77707 \$3137 \$3221 \$3220 \$18 VSS XNR201
* cell instance $77710 m90 *1 869.68,2237.5
X$77710 \$3136 \$3137 \$18 \$3065 VSS OR2101
* cell instance $77712 r0 *1 870.29,2237.5
X$77712 \$3139 \$18 \$3221 VSS INVR01
* cell instance $77713 m90 *1 899.69,2237.5
X$77713 \$18 \$3282 \$3225 VSS INVR02
* cell instance $77715 r0 *1 907.97,2237.5
X$77715 \$3139 \$3282 \$18 \$3065 VSS OR2101
* cell instance $77767 r0 *1 1422.62,2237.5
X$77767 \$18 \$3143 \$3067 VSS INVR03
* cell instance $77773 r0 *1 1543.94,2237.5
X$77773 \$18 \$2926 \$3103 VSS INVR03
* cell instance $77775 r0 *1 1560.74,2237.5
X$77775 \$18 \$3064 \$2978 VSS INVR02
* cell instance $77778 r0 *1 1587.35,2237.5
X$77778 \$18 \$3232 \$3103 VSS INVR06
* cell instance $77780 r0 *1 1626.14,2237.5
X$77780 \$18 \$3233 \$3234 VSS INVR03
* cell instance $77787 m90 *1 1691.92,2237.5
X$77787 \$18 \$2925 \$2835 \$3149 VSS AND201
* cell instance $77789 r0 *1 1694.27,2237.5
X$77789 \$3236 \$18 \$3235 VSS INVR05
* cell instance $77790 m90 *1 1757.27,2237.5
X$77790 \$3238 \$3232 \$3149 \$18 VSS XNR201
* cell instance $77794 m90 *1 1788.95,2237.5
X$77794 \$18 \$2981 \$3239 VSS INVR03
* cell instance $77795 m90 *1 1805.75,2237.5
X$77795 \$18 \$3240 \$2981 VSS INVR03
* cell instance $77802 r0 *1 1927.48,2237.5
X$77802 \$18 \$3243 \$3152 VSS INVR02
* cell instance $77808 m90 *1 2072.98,2237.5
X$77808 \$18 \$3246 \$2772 VSS INVR02
* cell instance $77809 r0 *1 2072.98,2237.5
X$77809 \$18 \$3067 \$3246 VSS INVR02
* cell instance $77811 r0 *1 2093.48,2237.5
X$77811 \$18 \$2987 \$3247 VSS INVR03
* cell instance $77816 r0 *1 2131.47,2237.5
X$77816 \$18 \$3248 \$2991 VSS INVR02
* cell instance $77819 m90 *1 2178.6,2237.5
X$77819 \$18 \$2988 \$2928 \$3250 VSS AND201
* cell instance $77825 r0 *1 2211.12,2237.5
X$77825 \$18 \$2990 \$3073 VSS INVR03
* cell instance $77837 m90 *1 2330.52,2237.5
X$77837 \$18 \$3251 \$2835 \$3252 VSS AND201
* cell instance $77848 r0 *1 2400.77,2237.5
X$77848 \$18 \$3255 \$2835 \$3254 VSS AND201
* cell instance $78037 r0 *1 3926.58,2237.5
X$78037 \$18 \$1558 \$3082 VSS INVR06
* cell instance $78039 r0 *1 3960.78,2237.5
X$78039 \$18 \$3293 \$2640 \$2843 VSS AND201
* cell instance $78041 r0 *1 3988.39,2237.5
X$78041 \$18 \$3293 \$3206 VSS INVR03
* cell instance $78043 r0 *1 4007.29,2237.5
X$78043 \$18 \$3257 \$3206 VSS INVR06
* cell instance $78052 r0 *1 4095.85,2237.5
X$78052 \$18 \$3002 \$3205 VSS INVR03
* cell instance $78055 r0 *1 4114.75,2237.5
X$78055 \$18 \$3258 \$3205 VSS INVR06
* cell instance $78061 r0 *1 4174.75,2237.5
X$78061 \$18 \$3005 \$3204 VSS INVR03
* cell instance $78063 r0 *1 4193.65,2237.5
X$78063 \$18 \$3259 \$3204 VSS INVR06
* cell instance $78067 r0 *1 4237.8,2237.5
X$78067 \$3004 \$18 \$3006 VSS INVR01
* cell instance $78074 m90 *1 4313.06,2237.5
X$78074 \$18 \$3167 \$3011 VSS INVR03
* cell instance $78078 r0 *1 4316.66,2237.5
X$78078 \$18 \$3260 \$3012 VSS INVR06
* cell instance $78079 m90 *1 4358.66,2237.5
X$78079 \$3007 \$18 \$2855 VSS INVR01
* cell instance $78081 r0 *1 4366.98,2237.5
X$78081 \$18 \$3082 \$3172 VSS INVR02
* cell instance $78083 m90 *1 4405.95,2237.5
X$78083 \$18 \$3292 \$3167 VSS INVR02
* cell instance $78087 m90 *1 4435.95,2237.5
X$78087 \$18 \$3084 \$3292 VSS INVR02
* cell instance $78089 m90 *1 4452.75,2237.5
X$78089 \$18 \$3374 \$2855 VSS INVR02
* cell instance $78100 r0 *1 4569.74,2237.5
X$78100 \$18 \$3265 \$3090 \$2942 VSS AND201
* cell instance $78103 r0 *1 4608.15,2237.5
X$78103 \$18 \$2943 \$3180 VSS INVR02
* cell instance $78107 r0 *1 4638.15,2237.5
X$78107 \$18 \$3180 \$3181 VSS INVR03
* cell instance $78109 m90 *1 4671.75,2237.5
X$78109 \$18 \$3021 \$2942 VSS INVR03
* cell instance $78113 m90 *1 4703.68,2237.5
X$78113 \$18 \$2863 \$3090 VSS INVR02
* cell instance $78116 r0 *1 4705.96,2237.5
X$78116 \$3267 \$2660 \$3312 \$18 VSS XNR201
* cell instance $78117 r0 *1 4743.77,2237.5
X$78117 \$3268 \$18 \$3181 \$2528 VSS NOR201
* cell instance $78118 m90 *1 4794.17,2237.5
X$78118 \$18 \$2560 \$3187 VSS INVR03
* cell instance $78119 r0 *1 4794.17,2237.5
X$78119 \$18 \$2867 \$3189 VSS INVR02
* cell instance $78121 r0 *1 4814.18,2237.5
X$78121 \$18 \$3270 \$3267 VSS INVR02
* cell instance $78125 r0 *1 4847.78,2237.5
X$78125 \$18 \$2566 \$2808 VSS INVR02
* cell instance $78130 r0 *1 4964.37,2237.5
X$78130 \$18 \$3031 \$3273 VSS INVR03
* cell instance $78133 r0 *1 4994.37,2237.5
X$78133 \$18 \$3268 \$2754 VSS INVR03
* cell instance $78137 m90 *1 5041.39,2237.5
X$78137 \$18 \$2444 \$3045 VSS INVR02
* cell instance $78233 r0 *1 5790.1,2237.5
X$78233 \$18 \$3278 \$1479 VSS INVR06
* cell instance $78619 r0 *1 94.2,2769.7
X$78619 \$18 \$4584 \$4519 VSS INVR03
* cell instance $78620 r0 *1 111.51,2769.7
X$78620 \$18 \$4309 \$4685 VSS INVR03
* cell instance $78622 r0 *1 157.71,2769.7
X$78622 \$4081 \$4411 \$3863 \$18 VSS XNR201
* cell instance $78626 m90 *1 231.22,2769.7
X$78626 \$18 \$4422 \$4683 VSS INVR02
* cell instance $78629 r0 *1 258.02,2769.7
X$78629 \$4417 \$18 \$4087 VSS INVR01
* cell instance $78630 r0 *1 270.62,2769.7
X$78630 \$18 \$4691 \$4413 VSS INVR02
* cell instance $78632 m90 *1 313.52,2769.7
X$78632 \$4421 \$4691 \$18 \$4417 VSS OR2101
* cell instance $78636 r0 *1 326.43,2769.7
X$78636 \$4423 \$4737 \$18 \$4738 VSS OR2101
* cell instance $78637 r0 *1 348.47,2769.7
X$78637 \$18 \$4587 \$4434 VSS INVR03
* cell instance $78639 r0 *1 365.27,2769.7
X$78639 \$4423 \$18 \$4428 VSS INVR05
* cell instance $78640 r0 *1 390.47,2769.7
X$78640 \$18 \$4089 \$4428 VSS INVR02
* cell instance $78642 r0 *1 412.06,2769.7
X$78642 \$18 \$4097 \$4189 VSS INVR03
* cell instance $78645 m90 *1 463.06,2769.7
X$78645 \$4181 \$4589 \$18 \$3614 VSS OR2101
* cell instance $78649 r0 *1 474.48,2769.7
X$78649 \$4181 \$4590 \$18 \$3614 VSS OR2101
* cell instance $78652 m90 *1 522.47,2769.7
X$78652 \$4530 \$18 \$4591 \$4592 \$4593 VSS ADNR01
* cell instance $78654 r0 *1 527.27,2769.7
X$78654 \$18 \$4664 \$4594 VSS INVR02
* cell instance $78657 m90 *1 578.87,2769.7
X$78657 \$18 \$4533 \$4532 VSS INVR03
* cell instance $78664 m90 *1 627.2,2769.7
X$78664 \$18 \$4596 \$4533 VSS INVR03
* cell instance $78671 m90 *1 752.03,2769.7
X$78671 \$3629 \$4105 \$4332 \$4336 \$4598 \$4599 \$18 VSS AND501
* cell instance $78677 m90 *1 818.32,2769.7
X$78677 \$18 \$4599 \$4601 \$3620 VSS AND201
* cell instance $78682 r0 *1 839.78,2769.7
X$78682 \$4602 \$18 \$4265 VSS INVR01
* cell instance $78687 m90 *1 883.75,2769.7
X$78687 \$4603 \$18 \$4604 VSS INVR01
* cell instance $78692 m90 *1 951.56,2769.7
X$78692 \$3724 \$4607 \$3634 \$4443 \$3632 \$18 VSS AND401
* cell instance $78695 r0 *1 954.96,2769.7
X$78695 \$4607 \$18 \$3724 VSS INVR01
* cell instance $78697 r0 *1 967.56,2769.7
X$78697 \$18 \$4440 \$4697 VSS INVR02
* cell instance $78704 m90 *1 1040.79,2769.7
X$78704 \$18 \$4445 \$4601 VSS INVR02
* cell instance $78708 m90 *1 1073.4,2769.7
X$78708 \$4443 \$18 \$4542 VSS INVR05
* cell instance $78712 r0 *1 1086.2,2769.7
X$78712 \$18 \$4342 \$4542 VSS INVR03
* cell instance $78713 r0 *1 1103,2769.7
X$78713 \$18 \$4670 \$3407 \$4343 VSS AND201
* cell instance $78714 r0 *1 1128.2,2769.7
X$78714 \$18 \$4670 \$4544 VSS INVR03
* cell instance $78721 m90 *1 1205.01,2769.7
X$78721 \$18 \$4612 \$4611 VSS INVR02
* cell instance $78724 r0 *1 1209.24,2769.7
X$78724 \$18 \$4613 \$4544 VSS INVR06
* cell instance $78727 m90 *1 1277.52,2769.7
X$78727 \$4207 \$18 \$4546 VSS INVR05
* cell instance $78742 r0 *1 1377.61,2769.7
X$78742 \$18 \$4349 \$4546 VSS INVR03
* cell instance $78743 r0 *1 1394.41,2769.7
X$78743 \$18 \$4615 \$3887 VSS INVR02
* cell instance $78746 m90 *1 1439.7,2769.7
X$78746 \$18 \$4549 \$3066 VSS INVR02
* cell instance $78749 r0 *1 1542.11,2769.7
X$78749 \$4618 \$18 \$4455 VSS INVR05
* cell instance $78752 r0 *1 1579.92,2769.7
X$78752 \$4620 \$18 \$4124 \$4619 VSS NOR201
* cell instance $78755 r0 *1 1620.84,2769.7
X$78755 \$18 \$4620 \$4678 VSS INVR02
* cell instance $78757 r0 *1 1637.64,2769.7
X$78757 \$18 \$4678 \$4270 VSS INVR03
* cell instance $78766 r0 *1 1714.45,2769.7
X$78766 \$18 \$4679 \$4621 VSS INVR03
* cell instance $78771 r0 *1 1835.38,2769.7
X$78771 \$18 \$3664 \$4555 VSS INVR03
* cell instance $78777 m90 *1 1906.78,2769.7
X$78777 \$18 \$4625 \$2835 \$4626 VSS AND201
* cell instance $78778 r0 *1 1906.78,2769.7
X$78778 \$18 \$4627 \$4215 VSS INVR02
* cell instance $78780 r0 *1 1933.33,2769.7
X$78780 \$18 \$4558 \$4461 \$4363 VSS AND201
* cell instance $78784 r0 *1 1965.17,2769.7
X$78784 \$4558 \$4629 \$18 \$4632 VSS OR2101
* cell instance $78786 r0 *1 1988.54,2769.7
X$78786 \$18 \$4630 \$4455 VSS INVR03
* cell instance $78793 r0 *1 2043.14,2769.7
X$78793 \$18 \$4275 \$4631 VSS INVR02
* cell instance $78800 m90 *1 2116.14,2769.7
X$78800 \$4370 \$18 \$4633 VSS INVR01
* cell instance $78802 m90 *1 2132.94,2769.7
X$78802 \$4472 \$4374 \$4560 \$18 VSS NND201
* cell instance $78805 m90 *1 2162.94,2769.7
X$78805 \$18 \$4636 \$4635 VSS INVR02
* cell instance $78808 r0 *1 2167.7,2769.7
X$78808 \$18 \$4560 \$4638 \$4635 VSS AND201
* cell instance $78811 r0 *1 2206.14,2769.7
X$78811 \$18 \$4475 \$4639 VSS INVR02
* cell instance $78815 m90 *1 2253.23,2769.7
X$78815 \$18 \$4755 \$4640 VSS INVR02
* cell instance $78825 m90 *1 2406.8,2769.7
X$78825 \$18 \$4376 \$4646 \$4377 VSS AND201
* cell instance $78828 m90 *1 2428.4,2769.7
X$78828 \$18 \$4648 \$4647 VSS INVR02
* cell instance $78830 r0 *1 2430.9,2769.7
X$78830 \$18 \$4384 \$4650 VSS INVR02
* cell instance $78833 m90 *1 2477.45,2769.7
X$78833 \$18 \$4382 \$4564 VSS INVR03
* cell instance $78834 m90 *1 2506.86,2769.7
X$78834 \$4651 \$4385 \$4168 \$18 \$4380 VSS OR3101
* cell instance $78836 m90 *1 2529.5,2769.7
X$78836 \$4651 \$4566 \$4564 \$18 VSS NND201
* cell instance $78841 r0 *1 2549.64,2769.7
X$78841 \$18 \$4566 \$4483 VSS INVR03
* cell instance $79632 m90 *1 124.21,3301.9
X$79632 \$5836 \$18 \$5983 VSS INVR01
* cell instance $79633 r0 *1 171.01,3301.9
X$79633 \$18 \$5637 \$6311 VSS INVR02
* cell instance $79634 m90 *1 213.01,3301.9
X$79634 \$18 \$5985 \$5386 \$6161 VSS AND201
* cell instance $79637 m90 *1 263.21,3301.9
X$79637 \$6311 \$5986 \$6161 \$18 VSS XNR201
* cell instance $79638 m90 *1 280.02,3301.9
X$79638 \$18 \$5314 \$5639 VSS INVR02
* cell instance $79639 m90 *1 309.42,3301.9
X$79639 \$18 \$5386 \$5987 VSS INVR06
* cell instance $79642 r0 *1 327.37,3301.9
X$79642 \$5986 \$18 \$6229 VSS INVR05
* cell instance $79644 m90 *1 381.97,3301.9
X$79644 \$18 \$5987 \$6202 VSS INVR06
* cell instance $79645 r0 *1 381.97,3301.9
X$79645 \$18 \$6165 \$6318 VSS INVR02
* cell instance $79648 r0 *1 411.97,3301.9
X$79648 \$18 \$5986 \$5405 VSS INVR03
* cell instance $79651 r0 *1 432.26,3301.9
X$79651 \$18 \$6318 \$6235 VSS INVR03
* cell instance $79653 m90 *1 486.86,3301.9
X$79653 \$6323 \$6237 \$6235 \$6246 \$6202 \$18 VSS AND401
* cell instance $79654 m90 *1 508.52,3301.9
X$79654 \$6239 \$6237 \$18 \$6207 VSS OR2101
* cell instance $79656 r0 *1 516.87,3301.9
X$79656 \$18 \$6326 \$6207 VSS INVR03
* cell instance $79658 r0 *1 538.15,3301.9
X$79658 \$18 \$6239 \$6212 VSS INVR03
* cell instance $79659 r0 *1 554.95,3301.9
X$79659 \$18 \$5993 \$6242 VSS INVR03
* cell instance $79662 m90 *1 610.15,3301.9
X$79662 \$18 \$5992 \$6165 \$6245 VSS AND201
* cell instance $79664 m90 *1 626.96,3301.9
X$79664 \$18 \$5031 \$6246 VSS INVR03
* cell instance $79666 r0 *1 631.75,3301.9
X$79666 \$6245 \$6329 \$6247 \$18 VSS NND201
* cell instance $79668 m90 *1 671.96,3301.9
X$79668 \$6212 \$6247 \$18 \$5406 VSS OR2101
* cell instance $79671 r0 *1 678.77,3301.9
X$79671 \$18 \$6212 \$6249 VSS INVR03
* cell instance $79672 r0 *1 695.57,3301.9
X$79672 \$18 \$6333 \$6332 \$6250 VSS AND201
* cell instance $79676 r0 *1 734.82,3301.9
X$79676 \$18 \$6165 \$5998 VSS INVR06
* cell instance $79683 r0 *1 803.84,3301.9
X$79683 \$18 \$6334 \$6001 VSS INVR03
* cell instance $79687 r0 *1 837.65,3301.9
X$79687 \$18 \$4434 \$6413 VSS INVR02
* cell instance $79688 r0 *1 854.46,3301.9
X$79688 \$18 \$6413 \$6414 VSS INVR02
* cell instance $79690 r0 *1 873.36,3301.9
X$79690 \$18 \$6414 \$6412 VSS INVR02
* cell instance $79692 r0 *1 892.26,3301.9
X$79692 \$18 \$6412 \$6007 VSS INVR02
* cell instance $79694 r0 *1 914.07,3301.9
X$79694 \$18 \$6004 \$6166 VSS INVR02
* cell instance $79696 r0 *1 935.67,3301.9
X$79696 \$18 \$6006 \$3227 \$6007 VSS AND201
* cell instance $79700 r0 *1 980.95,3301.9
X$79700 \$18 \$6258 \$5039 VSS INVR02
* cell instance $79704 r0 *1 1016.41,3301.9
X$79704 \$5524 \$6336 \$6116 \$18 VSS XNR201
* cell instance $79705 r0 *1 1054.21,3301.9
X$79705 \$18 \$6166 \$6455 VSS INVR02
* cell instance $79706 r0 *1 1071.02,3301.9
X$79706 \$18 \$3227 \$6336 VSS INVR02
* cell instance $79713 r0 *1 1130.39,3301.9
X$79713 \$18 \$6171 \$5676 VSS INVR02
* cell instance $79716 r0 *1 1160.4,3301.9
X$79716 \$18 \$6170 \$6171 VSS INVR03
* cell instance $79720 r0 *1 1189.3,3301.9
X$79720 \$6216 \$18 \$6171 \$5414 VSS NOR201
* cell instance $79723 r0 *1 1236.11,3301.9
X$79723 \$18 \$6216 \$6340 VSS INVR02
* cell instance $79726 r0 *1 1261.84,3301.9
X$79726 \$6341 \$5141 \$6268 \$18 VSS NND201
* cell instance $79727 r0 *1 1278.64,3301.9
X$79727 \$18 \$6174 \$6342 VSS INVR02
* cell instance $79728 r0 *1 1296.12,3301.9
X$79728 \$18 \$6343 \$6270 VSS INVR03
* cell instance $79731 r0 *1 1325.61,3301.9
X$79731 \$18 \$3227 \$6344 VSS INVR02
* cell instance $79732 r0 *1 1342.41,3301.9
X$79732 \$6346 \$6021 \$6272 \$18 \$5429 VSS OR3101
* cell instance $79736 r0 *1 1390.76,3301.9
X$79736 \$18 \$6348 \$6273 VSS INVR03
* cell instance $79739 r0 *1 1420.77,3301.9
X$79739 \$4983 \$6274 \$5770 \$18 VSS NND201
* cell instance $79742 r0 *1 1441.63,3301.9
X$79742 \$18 \$6349 \$6175 VSS INVR03
* cell instance $79745 r0 *1 1467.57,3301.9
X$79745 \$18 \$5686 \$6041 VSS INVR06
* cell instance $79746 r0 *1 1497.58,3301.9
X$79746 \$18 \$4454 \$5693 VSS INVR06
* cell instance $79747 r0 *1 1526.98,3301.9
X$79747 \$18 \$6350 \$6280 VSS INVR03
* cell instance $79751 m90 *1 1586.55,3301.9
X$79751 \$6346 \$6348 \$6281 \$18 \$6353 VSS OR3101
* cell instance $79752 r0 *1 1586.55,3301.9
X$79752 \$18 \$6354 \$6174 VSS INVR02
* cell instance $79753 r0 *1 1603.35,3301.9
X$79753 \$18 \$6355 \$5260 VSS INVR03
* cell instance $79754 r0 *1 1620.15,3301.9
X$79754 \$18 \$6123 \$6439 VSS INVR02
* cell instance $79755 r0 *1 1636.95,3301.9
X$79755 \$18 \$6439 \$6282 VSS INVR03
* cell instance $79756 r0 *1 1653.75,3301.9
X$79756 \$18 \$6358 \$6025 VSS INVR02
* cell instance $79757 m90 *1 1696.92,3301.9
X$79757 \$18 \$6353 \$4902 \$5764 VSS AND201
* cell instance $79759 r0 *1 1697.84,3301.9
X$79759 \$6180 \$6361 \$18 \$6360 VSS OR2101
* cell instance $79760 m90 *1 1739.84,3301.9
X$79760 \$6185 \$6125 \$18 \$6032 VSS OR2101
* cell instance $79763 r0 *1 1751.81,3301.9
X$79763 \$18 \$6128 \$6031 \$5255 VSS AND201
* cell instance $79766 m90 *1 1798.86,3301.9
X$79766 \$6030 \$18 \$5863 VSS INVR01
* cell instance $79769 r0 *1 1807.02,3301.9
X$79769 \$18 \$6367 \$6366 \$6180 VSS AND201
* cell instance $79770 r0 *1 1833.66,3301.9
X$79770 \$18 \$6036 \$6366 \$5959 VSS AND201
* cell instance $79772 r0 *1 1859.64,3301.9
X$79772 \$18 \$6369 \$6286 VSS INVR02
* cell instance $79776 r0 *1 1890.92,3301.9
X$79776 \$18 \$6286 \$6056 VSS INVR03
* cell instance $79777 m90 *1 1924.52,3301.9
X$79777 \$18 \$5863 \$6185 VSS INVR02
* cell instance $79786 r0 *1 1985.89,3301.9
X$79786 \$6038 \$18 \$6046 VSS INVR05
* cell instance $79788 r0 *1 2011.09,3301.9
X$79788 \$18 \$6037 \$5704 VSS INVR03
* cell instance $79792 m90 *1 2086.58,3301.9
X$79792 \$6297 \$6373 \$6210 \$18 VSS XNR201
* cell instance $79793 r0 *1 2086.59,3301.9
X$79793 \$18 \$6210 \$6375 VSS INVR02
* cell instance $79796 r0 *1 2113.31,3301.9
X$79796 \$18 \$3912 \$6206 VSS INVR02
* cell instance $79805 r0 *1 2194.67,3301.9
X$79805 \$18 \$6057 \$6307 VSS INVR03
* cell instance $79806 r0 *1 2211.47,3301.9
X$79806 \$18 \$6050 \$6307 VSS INVR04
* cell instance $79809 r0 *1 2245.67,3301.9
X$79809 \$18 \$6206 \$6378 VSS INVR02
* cell instance $79813 r0 *1 2266.11,3301.9
X$79813 \$18 \$6297 \$6050 VSS INVR06
* cell instance $79818 r0 *1 2320.71,3301.9
X$79818 \$18 \$3743 \$6297 VSS INVR06
* cell instance $79819 r0 *1 2350.11,3301.9
X$79819 \$18 \$6381 \$6297 VSS INVR06
* cell instance $79820 r0 *1 2379.51,3301.9
X$79820 \$18 \$6382 \$6298 VSS INVR06
* cell instance $80016 m90 *1 3999.74,3301.9
X$80016 \$18 \$6383 \$6199 VSS INVR06
* cell instance $80018 r0 *1 3999.74,3301.9
X$80018 \$18 \$6384 \$3079 VSS INVR06
* cell instance $80019 r0 *1 4029.14,3301.9
X$80019 \$18 \$2844 \$6199 VSS INVR03
* cell instance $80020 r0 *1 4045.94,3301.9
X$80020 \$18 \$3000 \$6063 VSS INVR03
* cell instance $80359 r0 *1 6759.87,3301.9
X$80359 \$18 \$6385 \$5187 VSS INVR06
* cell instance $80623 r0 *1 89.26,3479.3
X$80623 \$6615 \$18 \$6766 VSS INVR05
* cell instance $80626 m90 *1 163.41,3479.3
X$80626 \$18 \$6769 \$5728 VSS INVR04
* cell instance $80628 r0 *1 184.41,3479.3
X$80628 \$18 \$7039 \$6772 VSS INVR03
* cell instance $80633 r0 *1 228.65,3479.3
X$80633 \$18 \$6507 \$6723 VSS INVR03
* cell instance $80640 r0 *1 322.26,3479.3
X$80640 \$18 \$5728 \$6852 VSS INVR02
* cell instance $80642 r0 *1 342.66,3479.3
X$80642 \$18 \$6590 \$6777 VSS INVR03
* cell instance $80644 r0 *1 460.26,3479.3
X$80644 \$18 \$6782 \$6601 VSS INVR02
* cell instance $80645 r0 *1 477.06,3479.3
X$80645 \$6323 \$6239 \$6207 \$18 VSS NND201
* cell instance $80650 r0 *1 520.26,3479.3
X$80650 \$18 \$6723 \$6229 VSS INVR03
* cell instance $80652 r0 *1 541.88,3479.3
X$80652 \$18 \$6598 \$6855 VSS INVR02
* cell instance $80654 r0 *1 651.06,3479.3
X$80654 \$18 \$6518 \$6789 VSS INVR03
* cell instance $80658 r0 *1 783.39,3479.3
X$80658 \$6860 \$18 \$6791 VSS INVR05
* cell instance $80660 r0 *1 812.87,3479.3
X$80660 \$18 \$6333 \$6861 VSS INVR02
* cell instance $80663 r0 *1 846.25,3479.3
X$80663 \$18 \$6727 \$6793 VSS INVR03
* cell instance $80669 r0 *1 916.19,3479.3
X$80669 \$18 \$6523 \$6865 VSS INVR02
* cell instance $80674 r0 *1 948.52,3479.3
X$80674 \$18 \$6730 \$6865 \$6003 VSS AND201
* cell instance $80679 r0 *1 981.5,3479.3
X$80679 \$18 \$6729 \$6795 VSS INVR06
* cell instance $80680 r0 *1 1010.9,3479.3
X$80680 \$6727 \$18 \$6521 \$6612 \$6865 VSS ADNR01
* cell instance $80682 m90 *1 1057.71,3479.3
X$80682 \$18 \$6615 \$6761 VSS INVR03
* cell instance $80685 m90 *1 1087.71,3479.3
X$80685 \$18 \$6761 \$6612 VSS INVR03
* cell instance $80687 m90 *1 1113.62,3479.3
X$80687 \$18 \$6872 \$6875 \$6729 VSS AND201
* cell instance $80690 m90 *1 1149.51,3479.3
X$80690 \$18 \$6875 \$6616 \$6622 VSS AND201
* cell instance $80697 r0 *1 1186.64,3479.3
X$80697 \$18 \$6617 \$6013 VSS INVR06
* cell instance $80698 m90 *1 1237.04,3479.3
X$80698 \$6733 \$6879 \$18 \$4983 VSS OR2101
* cell instance $80701 m90 *1 1265.48,3479.3
X$80701 \$18 \$6979 \$6880 VSS INVR03
* cell instance $80704 r0 *1 1269.1,3479.3
X$80704 \$6730 \$6881 \$6882 \$6883 \$6980 \$18 VSS AND401
* cell instance $80706 r0 *1 1306.9,3479.3
X$80706 \$18 \$6884 \$6981 VSS INVR02
* cell instance $80715 r0 *1 1382.78,3479.3
X$80715 \$18 \$6623 \$6733 VSS INVR03
* cell instance $80717 r0 *1 1399.65,3479.3
X$80717 \$6806 \$6885 \$18 \$6807 VSS OR2101
* cell instance $80720 r0 *1 1433.25,3479.3
X$80720 \$6625 \$18 \$5753 VSS INVR01
* cell instance $80723 r0 *1 1452.78,3479.3
X$80723 \$18 \$6360 \$6809 VSS INVR06
* cell instance $80724 r0 *1 1482.18,3479.3
X$80724 \$18 \$6736 \$6726 VSS INVR06
* cell instance $80725 m90 *1 1536.78,3479.3
X$80725 \$18 \$6627 \$6620 \$6890 VSS AND201
* cell instance $80727 r0 *1 1539.3,3479.3
X$80727 \$18 \$7060 \$6366 VSS INVR03
* cell instance $80729 r0 *1 1565.03,3479.3
X$80729 \$18 \$6280 \$6642 VSS INVR03
* cell instance $80732 m90 *1 1620.23,3479.3
X$80732 \$18 \$6883 \$6893 \$6739 VSS AND201
* cell instance $80734 m90 *1 1637.03,3479.3
X$80734 \$18 \$6894 \$6893 VSS INVR02
* cell instance $80735 m90 *1 1674.83,3479.3
X$80735 \$6632 \$6178 \$6896 \$18 VSS XNR201
* cell instance $80737 m90 *1 1702.95,3479.3
X$80737 \$18 \$6281 \$5255 \$6124 VSS AND201
* cell instance $80739 r0 *1 1705.58,3479.3
X$80739 \$18 \$6360 \$6740 VSS INVR02
* cell instance $80743 r0 *1 1737.19,3479.3
X$80743 \$6816 \$6902 \$18 \$6740 VSS OR2101
* cell instance $80744 r0 *1 1758.19,3479.3
X$80744 \$6739 \$6687 \$18 \$6740 VSS OR2101
* cell instance $80745 r0 *1 1779.19,3479.3
X$80745 \$18 \$6634 \$6739 VSS INVR02
* cell instance $80749 m90 *1 1831.79,3479.3
X$80749 \$18 \$6180 \$6638 VSS INVR02
* cell instance $80753 r0 *1 1843.39,3479.3
X$80753 \$6819 \$6903 \$18 \$6644 VSS OR2101
* cell instance $80760 r0 *1 1995.7,3479.3
X$80760 \$18 \$6645 \$6180 VSS INVR03
* cell instance $80765 r0 *1 2041.79,3479.3
X$80765 \$18 \$6905 \$6825 VSS INVR03
* cell instance $80767 r0 *1 2087.99,3479.3
X$80767 \$18 \$6905 \$6826 VSS INVR03
* cell instance $80769 m90 *1 2129.89,3479.3
X$80769 \$18 \$6908 \$6829 VSS INVR02
* cell instance $80770 r0 *1 2129.89,3479.3
X$80770 \$18 \$6829 \$6905 VSS INVR03
* cell instance $80773 r0 *1 2157.16,3479.3
X$80773 \$18 \$6055 \$6298 VSS INVR03
* cell instance $80784 m90 *1 2289.55,3479.3
X$80784 \$6832 \$6747 \$18 \$6912 \$6833 VSS NOR301
* cell instance $80786 r0 *1 2289.55,3479.3
X$80786 \$18 \$6913 \$6834 VSS INVR06
* cell instance $80789 r0 *1 2335.75,3479.3
X$80789 \$18 \$6748 \$6835 VSS INVR06
* cell instance $80792 m90 *1 2394.56,3479.3
X$80792 \$6915 \$6747 \$6653 \$18 VSS NND201
* cell instance $80793 r0 *1 2394.56,3479.3
X$80793 \$6916 \$18 \$6748 VSS INVR05
* cell instance $80812 m90 *1 2582.96,3479.3
X$80812 \$18 \$6917 \$6918 \$6919 VSS AND201
* cell instance $81000 r0 *1 4069.8,3479.3
X$81000 \$18 \$6920 \$3258 VSS INVR06
* cell instance $81009 r0 *1 4159.81,3479.3
X$81009 \$18 \$6749 \$6837 VSS INVR06
* cell instance $81604 m90 *1 197.94,4011.5
X$81604 \$18 \$8268 \$7254 \$8812 VSS AND201
* cell instance $81606 r0 *1 206.51,4011.5
X$81606 \$18 \$8268 \$9056 VSS INVR02
* cell instance $81607 r0 *1 225.12,4011.5
X$81607 \$18 \$9056 \$8523 VSS INVR03
* cell instance $81610 r0 *1 246.12,4011.5
X$81610 \$18 \$8528 \$9092 VSS INVR02
* cell instance $81611 r0 *1 262.92,4011.5
X$81611 \$8405 \$18 \$8528 VSS INVR01
* cell instance $81614 m90 *1 317.86,4011.5
X$81614 \$18 \$7254 \$8815 VSS INVR06
* cell instance $81616 m90 *1 364.52,4011.5
X$81616 \$7780 \$7247 \$7762 \$7332 \$8529 \$18 VSS AND401
* cell instance $81617 r0 *1 364.53,4011.5
X$81617 \$7772 \$18 \$8137 \$7780 VSS NOR201
* cell instance $81619 r0 *1 400.45,4011.5
X$81619 \$18 \$8531 \$8638 VSS INVR03
* cell instance $81622 r0 *1 434.85,4011.5
X$81622 \$18 \$8536 \$9057 VSS INVR02
* cell instance $81624 r0 *1 451.65,4011.5
X$81624 \$18 \$9057 \$8819 VSS INVR03
* cell instance $81626 r0 *1 477.1,4011.5
X$81626 \$18 \$5730 \$8960 VSS INVR02
* cell instance $81629 r0 *1 510.7,4011.5
X$81629 \$18 \$8356 \$5730 VSS INVR02
* cell instance $81632 r0 *1 534.42,4011.5
X$81632 \$8964 \$8133 \$7769 \$8132 \$8532 \$18 VSS AND401
* cell instance $81634 r0 *1 577.37,4011.5
X$81634 \$18 \$8532 \$8825 VSS INVR03
* cell instance $81636 r0 *1 594.17,4011.5
X$81636 \$18 \$8918 \$8825 VSS INVR06
* cell instance $81637 m90 *1 640.37,4011.5
X$81637 \$18 \$8964 \$8966 VSS INVR02
* cell instance $81640 r0 *1 652.07,4011.5
X$81640 \$18 \$8543 \$8544 VSS INVR02
* cell instance $81644 m90 *1 704.33,4011.5
X$81644 \$8967 \$18 \$8547 VSS INVR05
* cell instance $81645 r0 *1 704.34,4011.5
X$81645 \$18 \$8143 \$7088 VSS INVR03
* cell instance $81647 r0 *1 826.16,4011.5
X$81647 \$18 \$8831 \$8745 VSS INVR02
* cell instance $81656 r0 *1 904.08,4011.5
X$81656 \$18 \$8971 \$8922 VSS INVR03
* cell instance $81659 r0 *1 922.98,4011.5
X$81659 \$18 \$8832 \$8922 VSS INVR06
* cell instance $81661 r0 *1 961.04,4011.5
X$81661 \$18 \$9205 \$8832 VSS INVR06
* cell instance $81662 r0 *1 990.44,4011.5
X$81662 \$18 \$8548 \$8834 VSS INVR03
* cell instance $81666 r0 *1 1025.89,4011.5
X$81666 \$18 \$8835 \$8155 VSS INVR02
* cell instance $81668 m90 *1 1062.7,4011.5
X$81668 \$18 \$8973 \$8835 VSS INVR02
* cell instance $81670 r0 *1 1146.71,4011.5
X$81670 \$18 \$8556 \$8560 VSS INVR02
* cell instance $81672 m90 *1 1183.51,4011.5
X$81672 \$18 \$9104 \$8838 VSS INVR02
* cell instance $81674 r0 *1 1183.51,4011.5
X$81674 \$8838 \$8976 \$9105 \$18 VSS PDDR04
* cell instance $81675 m90 *1 1267.51,4011.5
X$81675 \$18 \$8326 \$8841 VSS INVR02
* cell instance $81676 m90 *1 1288.51,4011.5
X$81676 \$8843 \$8162 \$18 \$8838 VSS OR2101
* cell instance $81678 r0 *1 1293.5,4011.5
X$81678 \$18 \$8729 \$8844 VSS INVR03
* cell instance $81679 r0 *1 1310.3,4011.5
X$81679 \$18 \$8843 \$8166 VSS INVR03
* cell instance $81685 r0 *1 1357.1,4011.5
X$81685 \$18 \$8162 \$9210 VSS INVR02
* cell instance $81687 m90 *1 1394.33,4011.5
X$81687 \$18 \$8841 \$8565 VSS INVR02
* cell instance $81693 r0 *1 1418.26,4011.5
X$81693 \$18 \$8574 \$8024 VSS INVR03
* cell instance $81696 r0 *1 1439.63,4011.5
X$81696 \$18 \$8848 \$8983 VSS INVR02
* cell instance $81700 r0 *1 1523.5,4011.5
X$81700 \$18 \$8264 \$8575 VSS INVR02
* cell instance $81702 r0 *1 1542.73,4011.5
X$81702 \$18 \$8171 \$8848 VSS INVR02
* cell instance $81716 r0 *1 1655.06,4011.5
X$81716 \$18 \$5891 \$8944 VSS INVR02
* cell instance $81719 r0 *1 1676.54,4011.5
X$81719 \$18 \$3646 \$8580 VSS INVR06
* cell instance $81720 r0 *1 1705.94,4011.5
X$81720 \$18 \$8944 \$8170 VSS INVR03
* cell instance $81721 r0 *1 1722.74,4011.5
X$81721 \$8570 \$8989 \$18 \$8441 VSS OR2101
* cell instance $81722 r0 *1 1745.61,4011.5
X$81722 \$18 \$8990 \$8582 VSS INVR03
* cell instance $81726 r0 *1 1775.6,4011.5
X$81726 \$18 \$8989 \$8992 VSS INVR02
* cell instance $81728 r0 *1 1792.4,4011.5
X$81728 \$18 \$8857 \$8756 VSS INVR03
* cell instance $81729 r0 *1 1809.2,4011.5
X$81729 \$18 \$8854 \$8856 VSS INVR03
* cell instance $81731 r0 *1 1828.1,4011.5
X$81731 \$18 \$8994 \$8857 VSS INVR06
* cell instance $81732 r0 *1 1857.5,4011.5
X$81732 \$18 \$9111 \$8995 VSS INVR02
* cell instance $81733 r0 *1 1874.3,4011.5
X$81733 \$18 \$8583 \$7814 VSS INVR06
* cell instance $81736 r0 *1 1914.22,4011.5
X$81736 \$8586 \$7910 \$9215 \$18 VSS XNR201
* cell instance $81737 r0 *1 1952.02,4011.5
X$81737 \$18 \$8756 \$8036 VSS INVR02
* cell instance $81738 m90 *1 1985.62,4011.5
X$81738 \$8999 \$9108 \$9000 \$18 VSS NND201
* cell instance $81741 r0 *1 1996.55,4011.5
X$81741 \$18 \$8860 \$7910 VSS INVR06
* cell instance $81742 r0 *1 2025.95,4011.5
X$81742 \$18 \$8184 \$8860 VSS INVR06
* cell instance $81743 r0 *1 2055.35,4011.5
X$81743 \$18 \$8860 \$9082 VSS INVR02
* cell instance $81744 r0 *1 2072.15,4011.5
X$81744 \$18 \$9082 \$8863 VSS INVR03
* cell instance $81750 r0 *1 2323.19,4011.5
X$81750 \$18 \$9219 \$9005 VSS INVR02
* cell instance $81751 r0 *1 2339.99,4011.5
X$81751 \$8674 \$18 \$9005 VSS INVR05
* cell instance $81755 r0 *1 2379.94,4011.5
X$81755 \$8661 \$18 \$8596 VSS INVR05
* cell instance $81757 m90 *1 2430.94,4011.5
X$81757 \$9220 \$8672 \$18 \$8336 VSS OR2101
* cell instance $81759 r0 *1 2440.55,4011.5
X$81759 \$6912 \$9118 \$8766 \$18 VSS NND201
* cell instance $81761 r0 *1 2457.35,4011.5
X$81761 \$9007 \$18 \$8677 VSS INVR01
* cell instance $81762 m90 *1 2495.15,4011.5
X$81762 \$9121 \$18 \$8869 VSS INVR05
* cell instance $81763 r0 *1 2495.15,4011.5
X$81763 \$18 \$8677 \$8668 VSS INVR06
* cell instance $81766 r0 *1 2536.23,4011.5
X$81766 \$18 \$8769 \$9123 VSS INVR03
* cell instance $81770 m90 *1 2583.03,4011.5
X$81770 \$18 \$8599 \$8869 VSS INVR02
* cell instance $81772 m90 *1 2600.26,4011.5
X$81772 \$8766 \$8873 \$8872 \$18 VSS NND201
* cell instance $81775 m90 *1 2637.78,4011.5
X$81775 \$18 \$8676 \$8212 \$7569 VSS AND201
* cell instance $81778 m90 *1 2690.58,4011.5
X$81778 \$9014 \$8212 \$9012 \$7569 \$8875 \$18 VSS AOI401
* cell instance $81779 r0 *1 2691.36,4011.5
X$81779 \$18 \$8677 \$8875 VSS INVR03
* cell instance $81782 r0 *1 2725.05,4011.5
X$81782 \$18 \$9018 \$7624 \$9017 VSS AND201
* cell instance $81784 r0 *1 2755.82,4011.5
X$81784 \$18 \$7624 \$8212 \$7624 VSS AND201
* cell instance $81789 r0 *1 2792.84,4011.5
X$81789 \$18 \$7624 \$8772 VSS INVR02
* cell instance $81790 r0 *1 2810.84,4011.5
X$81790 \$18 \$8212 \$8696 VSS INVR02
* cell instance $81792 m90 *1 2852.84,4011.5
X$81792 \$18 \$8211 \$7624 \$8875 VSS AND201
* cell instance $81794 r0 *1 2861.25,4011.5
X$81794 \$8779 \$18 \$8881 VSS INVR05
* cell instance $81795 r0 *1 2903.25,4011.5
X$81795 \$8691 \$18 \$7566 VSS INVR05
* cell instance $81796 r0 *1 2928.45,4011.5
X$81796 \$8772 \$8612 \$18 \$8779 VSS OR2101
* cell instance $81798 r0 *1 2953.75,4011.5
X$81798 \$18 \$8608 \$9027 VSS INVR02
* cell instance $81814 r0 *1 3088.64,4011.5
X$81814 \$18 \$9028 \$8913 VSS INVR03
* cell instance $81816 r0 *1 3105.44,4011.5
X$81816 \$18 \$9030 \$8913 VSS INVR06
* cell instance $81819 r0 *1 3146.39,4011.5
X$81819 \$8618 \$18 \$8885 VSS INVR05
* cell instance $81823 r0 *1 3183.93,4011.5
X$81823 \$8888 \$8618 \$8779 \$18 VSS NND201
* cell instance $81828 r0 *1 3220.64,4011.5
X$81828 \$18 \$8888 \$9032 VSS INVR02
* cell instance $81830 r0 *1 3246.95,4011.5
X$81830 \$18 \$9032 \$8889 VSS INVR03
* cell instance $81835 m90 *1 3310.44,4011.5
X$81835 \$8473 \$18 \$8783 VSS INVR05
* cell instance $81839 m90 *1 3340.06,4011.5
X$81839 \$18 \$9034 \$8783 VSS INVR03
* cell instance $81932 r0 *1 4076.1,4011.5
X$81932 \$18 \$9382 \$5790 VSS INVR06
* cell instance $81965 r0 *1 4358.71,4011.5
X$81965 \$18 \$9035 \$9036 VSS INVR02
* cell instance $82107 r0 *1 5491.72,4011.5
X$82107 \$18 \$9037 \$9038 VSS INVR02
* cell instance $82134 m90 *1 5723.73,4011.5
X$82134 \$18 \$9040 \$9039 VSS INVR02
* cell instance $82151 r0 *1 5846.89,4011.5
X$82151 \$18 \$9041 \$8890 VSS INVR03
* cell instance $82167 r0 *1 5976.88,4011.5
X$82167 \$18 \$9136 \$9042 VSS INVR02
* cell instance $82169 r0 *1 5995.51,4011.5
X$82169 \$18 \$9043 \$8622 VSS INVR03
* cell instance $82190 r0 *1 6155.4,4011.5
X$82190 \$9044 \$18 \$8892 VSS INVR05
* cell instance $82193 r0 *1 6190.09,4011.5
X$82193 \$18 \$9045 \$8893 VSS INVR03
* cell instance $82209 r0 *1 6321,4011.5
X$82209 \$18 \$8901 \$8895 VSS INVR03
* cell instance $82213 r0 *1 6354.6,4011.5
X$82213 \$18 \$9047 \$8901 VSS INVR02
* cell instance $82253 r0 *1 6679.99,4011.5
X$82253 \$18 \$8896 \$8897 VSS INVR06
* cell instance $82511 r0 *1 8763.19,4011.5
X$82511 \$18 \$9049 \$9050 VSS INVR02
* cell instance $82518 r0 *1 8813.88,4011.5
X$82518 \$18 \$7214 \$8898 VSS INVR02
* cell instance $82520 r0 *1 8839.4,4011.5
X$82520 \$18 \$8898 \$8899 VSS INVR02
* cell instance $82528 r0 *1 3933.77,995.7
X$82528 \$18 \$941 \$1130 VSS INVR03
* cell instance $82531 r0 *1 3963.78,995.7
X$82531 \$18 \$202 \$1132 VSS INVR03
* cell instance $82535 r0 *1 3989.67,995.7
X$82535 \$18 \$1134 \$36 VSS INVR06
* cell instance $82536 r0 *1 4019.07,995.7
X$82536 \$18 \$1035 \$1135 VSS INVR03
* cell instance $82537 r0 *1 4035.87,995.7
X$82537 \$18 \$1137 \$1132 VSS INVR06
* cell instance $82539 r0 *1 4120.47,995.7
X$82539 \$18 \$1139 \$1277 VSS INVR03
* cell instance $82556 r0 *1 4341.39,995.7
X$82556 \$18 \$1192 \$1141 VSS INVR03
* cell instance $82560 r0 *1 4370.34,995.7
X$82560 \$18 \$1220 \$1078 VSS INVR02
* cell instance $82561 r0 *1 4387.14,995.7
X$82561 \$18 \$939 \$1192 VSS INVR02
* cell instance $82562 r0 *1 4403.94,995.7
X$82562 \$18 \$1046 \$1080 VSS INVR02
* cell instance $82564 r0 *1 4428.91,995.7
X$82564 \$18 \$1289 \$1143 VSS INVR03
* cell instance $82565 r0 *1 4445.71,995.7
X$82565 \$18 \$764 \$1038 VSS INVR03
* cell instance $82566 r0 *1 4462.51,995.7
X$82566 \$18 \$851 \$1145 VSS INVR03
* cell instance $82567 r0 *1 4479.31,995.7
X$82567 \$18 \$1044 \$1143 VSS INVR06
* cell instance $82568 m90 *1 4533.91,995.7
X$82568 \$18 \$939 \$1147 \$939 VSS AND201
* cell instance $82572 m90 *1 4572.37,995.7
X$82572 \$18 \$940 \$1113 \$1149 VSS AND201
* cell instance $82578 m90 *1 4623.75,995.7
X$82578 \$941 \$1147 \$18 \$1113 VSS OR2101
* cell instance $82582 m90 *1 4667.29,995.7
X$82582 \$1149 \$18 \$1114 VSS INVR05
* cell instance $82583 m90 *1 4684.09,995.7
X$82583 \$18 \$941 \$1114 VSS INVR02
* cell instance $82599 r0 *1 4804.09,995.7
X$82599 \$18 \$1049 \$952 VSS INVR03
* cell instance $82606 r0 *1 4865.91,995.7
X$82606 \$1154 \$1181 \$18 \$987 \$1052 VSS NOR301
* cell instance $82608 r0 *1 4903.71,995.7
X$82608 \$18 \$1181 \$1155 VSS INVR02
* cell instance $82609 m90 *1 4937.31,995.7
X$82609 \$18 \$951 \$1054 VSS INVR03
* cell instance $82610 m90 *1 4949.91,995.7
X$82610 \$1154 \$18 \$1054 VSS INVR01
* cell instance $82612 m90 *1 4998.99,995.7
X$82612 \$1061 \$1056 \$1059 \$1158 \$856 \$18 VSS NND401
* cell instance $82614 m90 *1 5032.56,995.7
X$82614 \$18 \$1162 \$1059 \$948 VSS AND201
* cell instance $82615 r0 *1 5032.56,995.7
X$82615 \$98 \$18 \$1059 VSS INVR05
* cell instance $82622 r0 *1 5100.18,995.7
X$82622 \$18 \$1165 \$1065 VSS INVR02
* cell instance $82623 r0 *1 5116.98,995.7
X$82623 \$18 \$1167 \$1066 VSS INVR06
* cell instance $82624 r0 *1 5146.38,995.7
X$82624 \$1176 \$18 \$1162 \$1169 VSS NOR201
* cell instance $82625 r0 *1 5179.98,995.7
X$82625 \$18 \$1176 \$1092 VSS INVR02
* cell instance $82631 r0 *1 5329.59,995.7
X$82631 \$18 \$1171 \$1068 VSS INVR03
* cell instance $82641 r0 *1 5406.85,995.7
X$82641 \$18 \$1172 \$1123 VSS INVR03
* cell instance $83077 r0 *1 4029.96,640.9
X$83077 \$18 \$758 \$757 VSS INVR02
* cell instance $83095 r0 *1 4435.26,640.9
X$83095 \$18 \$677 \$773 VSS INVR02
* cell instance $83096 r0 *1 4453.3,640.9
X$83096 \$18 \$447 \$773 VSS INVR04
* cell instance $83105 r0 *1 4524.71,640.9
X$83105 \$323 \$18 \$729 VSS INVR05
* cell instance $83106 r0 *1 4625.51,640.9
X$83106 \$778 \$18 \$630 VSS INVR01
* cell instance $83115 r0 *1 4797.75,640.9
X$83115 \$18 \$556 \$712 VSS INVR06
* cell instance $83116 r0 *1 4827.15,640.9
X$83116 \$18 \$724 \$740 VSS INVR03
* cell instance $83117 m90 *1 4860.75,640.9
X$83117 \$18 \$332 \$741 VSS INVR03
* cell instance $83120 r0 *1 4872.75,640.9
X$83120 \$18 \$617 \$806 VSS INVR02
* cell instance $83121 r0 *1 4889.55,640.9
X$83121 \$18 \$806 \$685 VSS INVR02
* cell instance $83122 r0 *1 4906.35,640.9
X$83122 \$721 \$18 \$785 VSS INVR01
* cell instance $83123 m90 *1 4931.55,640.9
X$83123 \$785 \$18 \$30 VSS INVR01
* cell instance $83129 m90 *1 5001.91,640.9
X$83129 \$18 \$597 \$694 VSS INVR06
* cell instance $83130 r0 *1 5001.91,640.9
X$83130 \$18 \$597 \$712 VSS INVR03
* cell instance $83131 r0 *1 5018.71,640.9
X$83131 \$18 \$686 \$691 VSS INVR02
* cell instance $83133 r0 *1 5043.85,640.9
X$83133 \$18 \$786 \$825 \$498 VSS AND201
* cell instance $83145 r0 *1 5140.65,640.9
X$83145 \$18 \$422 \$748 VSS INVR06
* cell instance $83146 m90 *1 5187.45,640.9
X$83146 \$18 \$693 \$789 VSS INVR02
* cell instance $83147 r0 *1 5187.45,640.9
X$83147 \$18 \$790 \$750 VSS INVR03
* cell instance $83148 r0 *1 5204.25,640.9
X$83148 \$18 \$791 \$30 \$422 VSS AND201
* cell instance $83158 r0 *1 5285.37,640.9
X$83158 \$18 \$793 \$794 VSS INVR02
* cell instance $83162 m90 *1 5342.82,640.9
X$83162 \$609 \$18 \$753 VSS INVR05
* cell instance $83164 r0 *1 5343.43,640.9
X$83164 \$18 \$702 \$754 VSS INVR06
* cell instance $83605 r0 *1 175.06,818.3
X$83605 \$18 \$923 \$895 VSS INVR06
* cell instance $83606 r0 *1 204.46,818.3
X$83606 \$18 \$839 \$924 VSS INVR06
* cell instance $83697 r0 *1 941.83,818.3
X$83697 \$18 \$926 \$925 VSS INVR06
* cell instance $83885 r0 *1 2467.26,818.3
X$83885 \$18 \$883 \$926 VSS INVR06
* cell instance $84047 r0 *1 3785.47,818.3
X$84047 \$18 \$895 \$928 VSS INVR06
* cell instance $84068 r0 *1 4155.09,818.3
X$84068 \$18 \$932 \$933 VSS INVR02
* cell instance $84079 r0 *1 4330.02,818.3
X$84079 \$18 \$844 \$935 VSS INVR03
* cell instance $84083 r0 *1 4360.03,818.3
X$84083 \$18 \$1078 \$936 VSS INVR02
* cell instance $84085 r0 *1 4477.63,818.3
X$84085 \$18 \$885 \$887 VSS INVR02
* cell instance $84088 r0 *1 4504.25,818.3
X$84088 \$18 \$938 \$849 VSS INVR02
* cell instance $84090 m90 *1 4542.6,818.3
X$84090 \$18 \$940 \$939 VSS INVR02
* cell instance $84095 r0 *1 4576.11,818.3
X$84095 \$18 \$848 \$911 VSS INVR03
* cell instance $84104 r0 *1 4636.8,818.3
X$84104 \$18 \$941 \$911 VSS INVR06
* cell instance $84106 r0 *1 4675.71,818.3
X$84106 \$18 \$775 \$942 VSS INVR02
* cell instance $84115 r0 *1 4739.64,818.3
X$84115 \$18 \$944 \$591 \$863 VSS AND201
* cell instance $84121 r0 *1 4797.13,818.3
X$84121 \$18 \$741 \$855 VSS INVR02
* cell instance $84125 r0 *1 4839.05,818.3
X$84125 \$18 \$855 \$856 VSS INVR03
* cell instance $84127 r0 *1 4855.85,818.3
X$84127 \$18 \$887 \$687 VSS INVR02
* cell instance $84128 r0 *1 4874.53,818.3
X$84128 \$223 \$18 \$892 VSS INVR05
* cell instance $84142 r0 *1 4990.45,818.3
X$84142 \$18 \$950 \$893 \$948 VSS AND201
* cell instance $84143 m90 *1 5036.65,818.3
X$84143 \$892 \$951 \$18 \$689 VSS OR2101
* cell instance $84144 r0 *1 5036.65,818.3
X$84144 \$18 \$498 \$952 VSS INVR06
* cell instance $84147 r0 *1 5076.24,818.3
X$84147 \$954 \$18 \$950 \$786 VSS NOR201
* cell instance $84148 m90 *1 5126.65,818.3
X$84148 \$18 \$893 \$892 VSS INVR03
* cell instance $84149 r0 *1 5126.65,818.3
X$84149 \$955 \$18 \$789 VSS INVR01
* cell instance $84153 m90 *1 5171.84,818.3
X$84153 \$18 \$956 \$893 VSS INVR02
* cell instance $84157 r0 *1 5182.34,818.3
X$84157 \$18 \$954 \$958 VSS INVR03
* cell instance $84160 m90 *1 5232.32,818.3
X$84160 \$18 \$956 \$959 VSS INVR02
* cell instance $84164 m90 *1 5264.08,818.3
X$84164 \$18 \$961 \$956 VSS INVR02
* cell instance $84170 r0 *1 5298.29,818.3
X$84170 \$18 \$963 \$962 VSS INVR06
* cell instance $84171 r0 *1 5327.69,818.3
X$84171 \$18 \$963 \$966 VSS INVR03
* cell instance $84172 r0 *1 5344.49,818.3
X$84172 \$18 \$754 \$966 VSS INVR06
* cell instance $84613 m90 *1 4244.42,463.5
X$84613 \$625 \$18 \$572 \$517 VSS NOR201
* cell instance $84616 m90 *1 4288.64,463.5
X$84616 \$404 \$308 \$516 \$18 VSS XNR201
* cell instance $84622 m90 *1 4359.21,463.5
X$84622 \$584 \$18 \$288 \$522 \$515 VSS AND301
* cell instance $84624 m90 *1 4379.31,463.5
X$84624 \$18 \$626 \$586 VSS INVR03
* cell instance $84642 r0 *1 4787.89,463.5
X$84642 \$18 \$460 \$530 VSS INVR02
* cell instance $84643 r0 *1 4804.69,463.5
X$84643 \$18 \$533 \$460 \$529 VSS AND201
* cell instance $84646 r0 *1 4887.06,463.5
X$84646 \$18 \$461 \$62 \$377 VSS AND201
* cell instance $84656 m90 *1 5168.71,463.5
X$84656 \$18 \$602 \$601 VSS INVR02
* cell instance $84657 r0 *1 5168.72,463.5
X$84657 \$18 \$602 \$228 VSS INVR03
* cell instance $84658 m90 *1 5202.79,463.5
X$84658 \$18 \$603 \$602 VSS INVR02
* cell instance $84662 m90 *1 5331.58,463.5
X$84662 \$18 \$609 \$608 VSS INVR02
* cell instance $85109 m90 *1 4335.17,286.1
X$85109 \$288 \$404 \$18 \$405 VSS OR2101
* cell instance $85111 m90 *1 4350.2,286.1
X$85111 \$446 \$18 \$201 VSS INVR01
* cell instance $85112 r0 *1 4350.2,286.1
X$85112 \$18 \$316 \$288 VSS INVR03
* cell instance $85115 m90 *1 4394.49,286.1
X$85115 \$18 \$159 \$287 VSS INVR04
* cell instance $85117 r0 *1 4402.89,286.1
X$85117 \$18 \$287 \$23 VSS INVR03
* cell instance $85119 r0 *1 4424.49,286.1
X$85119 \$18 \$410 \$317 \$166 VSS AND201
* cell instance $85121 m90 *1 4479.69,286.1
X$85121 \$18 \$411 \$323 \$369 VSS AND201
* cell instance $85127 r0 *1 4503.16,286.1
X$85127 \$18 \$413 \$368 VSS INVR06
* cell instance $85129 r0 *1 4542.01,286.1
X$85129 \$18 \$414 \$415 VSS INVR03
* cell instance $85133 r0 *1 4570.43,286.1
X$85133 \$18 \$416 \$369 VSS INVR02
* cell instance $85141 r0 *1 4632.49,286.1
X$85141 \$18 \$418 \$326 VSS INVR02
* cell instance $85145 r0 *1 4652.55,286.1
X$85145 \$421 \$18 \$420 \$209 VSS NOR201
* cell instance $85149 r0 *1 4739.55,286.1
X$85149 \$496 \$18 \$452 \$495 VSS NOR201
* cell instance $85152 r0 *1 4783.04,286.1
X$85152 \$18 \$166 \$457 VSS INVR06
* cell instance $85153 r0 *1 4812.44,286.1
X$85153 \$18 \$219 \$58 VSS INVR03
* cell instance $85154 r0 *1 4829.24,286.1
X$85154 \$18 \$426 \$441 VSS INVR03
* cell instance $85157 r0 *1 4849.73,286.1
X$85157 \$18 \$368 \$441 VSS INVR06
* cell instance $85158 r0 *1 4879.13,286.1
X$85158 \$429 \$18 \$461 \$336 VSS NOR201
* cell instance $85164 r0 *1 4949.36,286.1
X$85164 \$18 \$376 \$374 \$258 VSS AND201
* cell instance $85165 r0 *1 4974.56,286.1
X$85165 \$18 \$422 \$477 VSS INVR02
* cell instance $85166 r0 *1 4991.36,286.1
X$85166 \$18 \$477 \$377 VSS INVR03
* cell instance $85168 m90 *1 5034.45,286.1
X$85168 \$18 \$432 \$101 VSS INVR03
* cell instance $85174 r0 *1 5061.22,286.1
X$85174 \$18 \$433 \$473 VSS INVR02
* cell instance $85176 r0 *1 5081.25,286.1
X$85176 \$18 \$473 \$432 VSS INVR03
* cell instance $85178 m90 *1 5123.25,286.1
X$85178 \$18 \$338 \$432 \$377 VSS AND201
* cell instance $85181 r0 *1 5141.23,286.1
X$85181 \$18 \$341 \$28 \$377 VSS AND201
* cell instance $85185 r0 *1 5177.96,286.1
X$85185 \$18 \$437 \$228 \$377 VSS AND201
* cell instance $85189 r0 *1 5219.35,286.1
X$85189 \$438 \$18 \$437 \$345 VSS NOR201
* cell instance $85192 r0 *1 5266.97,286.1
X$85192 \$18 \$343 \$440 VSS INVR03
* cell instance $85659 m90 *1 4149.61,108.7
X$85659 \$18 \$19 \$38 VSS INVR03
* cell instance $85663 r0 *1 4161.6,108.7
X$85663 \$18 \$196 \$78 VSS INVR06
* cell instance $85665 m90 *1 4322.48,108.7
X$85665 \$159 \$24 \$237 \$236 \$18 VSS DEC24H
* cell instance $85667 m90 *1 4339.28,108.7
X$85667 \$18 \$287 \$240 VSS INVR03
* cell instance $85668 r0 *1 4340.69,108.7
X$85668 \$18 \$197 \$162 VSS INVR03
* cell instance $85670 r0 *1 4357.49,108.7
X$85670 \$18 \$197 \$83 VSS INVR04
* cell instance $85671 m90 *1 4396.71,108.7
X$85671 \$18 \$115 \$22 VSS INVR02
* cell instance $85675 m90 *1 4426.71,108.7
X$85675 \$18 \$41 \$287 VSS INVR02
* cell instance $85682 r0 *1 4497.26,108.7
X$85682 \$18 \$52 \$204 VSS INVR02
* cell instance $85684 m90 *1 4539.26,108.7
X$85684 \$18 \$49 \$205 \$53 VSS AND201
* cell instance $85686 m90 *1 4558.44,108.7
X$85686 \$205 \$167 \$120 \$18 VSS NND201
* cell instance $85689 r0 *1 4575.24,108.7
X$85689 \$167 \$18 \$204 VSS INVR01
* cell instance $85690 m90 *1 4606.31,108.7
X$85690 \$18 \$208 \$120 VSS INVR03
* cell instance $85693 m90 *1 4635.76,108.7
X$85693 \$18 \$209 \$248 \$166 VSS AND201
* cell instance $85694 m90 *1 4652.56,108.7
X$85694 \$18 \$210 \$54 VSS INVR03
* cell instance $85695 r0 *1 4653.17,108.7
X$85695 \$18 \$55 \$213 VSS INVR02
* cell instance $85696 r0 *1 4669.97,108.7
X$85696 \$88 \$18 \$204 VSS INVR01
* cell instance $85698 r0 *1 4729.11,108.7
X$85698 \$18 \$213 \$56 VSS INVR02
* cell instance $85699 r0 *1 4745.91,108.7
X$85699 \$18 \$168 \$214 VSS INVR02
* cell instance $85702 r0 *1 4801.11,108.7
X$85702 \$18 \$170 \$46 VSS INVR02
* cell instance $85705 r0 *1 4821.94,108.7
X$85705 \$18 \$170 \$184 VSS INVR02
* cell instance $85708 r0 *1 4845.04,108.7
X$85708 \$18 \$214 \$219 VSS INVR03
* cell instance $85709 r0 *1 4861.84,108.7
X$85709 \$18 \$57 \$254 VSS INVR02
* cell instance $85710 r0 *1 4879.25,108.7
X$85710 \$18 \$60 \$260 VSS INVR02
* cell instance $85711 m90 *1 4908.65,108.7
X$85711 \$59 \$18 \$29 VSS INVR01
* cell instance $85712 r0 *1 4910.57,108.7
X$85712 \$58 \$221 \$18 \$62 VSS OR2101
* cell instance $85715 r0 *1 4934.35,108.7
X$85715 \$62 \$18 \$222 VSS INVR05
* cell instance $85716 m90 *1 4977.67,108.7
X$85716 \$18 \$223 \$174 VSS INVR02
* cell instance $85723 m90 *1 5062.23,108.7
X$85723 \$18 \$177 \$64 VSS INVR03
* cell instance $85725 r0 *1 5071.24,108.7
X$85725 \$18 \$31 \$225 VSS INVR02
* cell instance $85732 r0 *1 5126.77,108.7
X$85732 \$65 \$28 \$226 \$18 VSS XNR201
* cell instance $85735 m90 *1 5197.68,108.7
X$85735 \$18 \$103 \$228 VSS INVR04
* cell instance $86198 r0 *1 4014.1,1350.5
X$86198 \$18 \$1666 \$1727 VSS INVR02
* cell instance $86200 m90 *1 4052.36,1350.5
X$86200 \$18 \$1110 \$1724 VSS INVR02
* cell instance $86207 r0 *1 4095.57,1350.5
X$86207 \$18 \$1667 \$1625 VSS INVR03
* cell instance $86213 m90 *1 4349.4,1350.5
X$86213 \$18 \$1573 \$1734 VSS INVR02
* cell instance $86214 r0 *1 4349.4,1350.5
X$86214 \$18 \$1570 \$1884 VSS INVR03
* cell instance $86215 r0 *1 4367.98,1350.5
X$86215 \$18 \$1672 \$1661 VSS INVR02
* cell instance $86217 m90 *1 4422.58,1350.5
X$86217 \$1734 \$1534 \$1672 \$18 VSS XNR201
* cell instance $86218 m90 *1 4439.38,1350.5
X$86218 \$18 \$1677 \$1676 VSS INVR02
* cell instance $86219 r0 *1 4439.38,1350.5
X$86219 \$18 \$1661 \$1607 VSS INVR03
* cell instance $86221 r0 *1 4465.85,1350.5
X$86221 \$1681 \$18 \$1679 \$1664 \$1576 VSS NND301
* cell instance $86223 m90 *1 4528.85,1350.5
X$86223 \$18 \$1677 \$1534 \$1573 VSS AND201
* cell instance $86226 r0 *1 4536.44,1350.5
X$86226 \$18 \$1577 \$1571 VSS INVR03
* cell instance $86230 m90 *1 4606.42,1350.5
X$86230 \$1297 \$1442 \$1149 \$1634 \$1664 \$1534 \$18 VSS AND501
* cell instance $86234 r0 *1 4609.66,1350.5
X$86234 \$1660 \$18 \$1611 \$1691 VSS NOR201
* cell instance $86236 r0 *1 4653.15,1350.5
X$86236 \$1694 \$18 \$1693 VSS INVR01
* cell instance $86238 r0 *1 4665.75,1350.5
X$86238 \$18 \$1451 \$1634 VSS INVR03
* cell instance $86241 m90 *1 4727.26,1350.5
X$86241 \$1581 \$18 \$1697 \$1458 \$1614 VSS NND301
* cell instance $86245 r0 *1 4747.77,1350.5
X$86245 \$1583 \$18 \$1698 \$1505 \$1537 VSS NND301
* cell instance $86246 r0 *1 4785.57,1350.5
X$86246 \$1681 \$1701 \$1702 \$1699 \$1611 \$18 VSS AOI401
* cell instance $86250 r0 *1 4850.15,1350.5
X$86250 \$18 \$1584 \$1639 VSS INVR03
* cell instance $86253 r0 *1 4877.64,1350.5
X$86253 \$18 \$1590 \$1639 VSS INVR06
* cell instance $86260 r0 *1 4952.42,1350.5
X$86260 \$18 \$1653 \$1587 VSS INVR03
* cell instance $86263 r0 *1 4978.43,1350.5
X$86263 \$18 \$1590 \$1653 VSS INVR02
* cell instance $86268 r0 *1 5009.56,1350.5
X$86268 \$18 \$1057 \$1310 VSS INVR02
* cell instance $86269 r0 *1 5026.36,1350.5
X$86269 \$1307 \$1709 \$18 \$1471 VSS OR2101
* cell instance $86270 r0 *1 5047.36,1350.5
X$86270 \$18 \$1708 \$1643 VSS INVR02
* cell instance $86271 r0 *1 5064.81,1350.5
X$86271 \$1711 \$18 \$1709 \$1643 \$1417 VSS AND301
* cell instance $86274 r0 *1 5108.46,1350.5
X$86274 \$1780 \$18 \$1713 \$1589 VSS NOR201
* cell instance $86276 r0 *1 5151.08,1350.5
X$86276 \$18 \$1780 \$1714 VSS INVR03
* cell instance $86278 r0 *1 5167.88,1350.5
X$86278 \$18 \$1716 \$1715 \$1590 VSS AND201
* cell instance $86281 m90 *1 5223.37,1350.5
X$86281 \$18 \$1717 \$1471 VSS INVR03
* cell instance $86286 m90 *1 5255.63,1350.5
X$86286 \$18 \$1715 \$1717 VSS INVR02
* cell instance $86293 m90 *1 5405.17,1350.5
X$86293 \$18 \$1719 \$1755 VSS INVR02
* cell instance $86298 r0 *1 5423.39,1350.5
X$86298 \$18 \$1646 \$1721 VSS INVR02
* cell instance $86302 r0 *1 5453.68,1350.5
X$86302 \$18 \$1715 \$1721 VSS INVR06
* cell instance $86729 r0 *1 3994.2,1527.9
X$86729 \$18 \$1972 \$1790 VSS INVR02
* cell instance $86735 r0 *1 4128.86,1527.9
X$86735 \$1976 \$18 \$2070 \$1238 VSS NOR201
* cell instance $86736 r0 *1 4162.46,1527.9
X$86736 \$18 \$1879 \$1972 VSS INVR02
* cell instance $86737 r0 *1 4179.26,1527.9
X$86737 \$18 \$1827 \$1882 VSS INVR02
* cell instance $86740 m90 *1 4226.05,1527.9
X$86740 \$18 \$1982 \$1981 VSS INVR02
* cell instance $86743 m90 *1 4269.05,1527.9
X$86743 \$1983 \$18 \$1948 \$1882 VSS NOR201
* cell instance $86747 m90 *1 4314.61,1527.9
X$86747 \$1985 \$18 \$1987 \$2074 \$1948 VSS NND301
* cell instance $86749 r0 *1 4314.62,1527.9
X$86749 \$18 \$1829 \$1667 VSS INVR02
* cell instance $86750 r0 *1 4331.42,1527.9
X$86750 \$18 \$1985 \$1627 VSS INVR03
* cell instance $86751 m90 *1 4365.03,1527.9
X$86751 \$18 \$1923 \$1948 VSS INVR03
* cell instance $86752 r0 *1 4366.29,1527.9
X$86752 \$1926 \$18 \$1676 VSS INVR01
* cell instance $86754 r0 *1 4378.89,1527.9
X$86754 \$18 \$1340 \$2029 VSS INVR02
* cell instance $86755 r0 *1 4395.69,1527.9
X$86755 \$18 \$2029 \$1949 VSS INVR03
* cell instance $86756 m90 *1 4429.29,1527.9
X$86756 \$18 \$1996 \$1292 VSS INVR02
* cell instance $86757 r0 *1 4429.29,1527.9
X$86757 \$1926 \$1987 \$18 \$1884 VSS OR2101
* cell instance $86758 r0 *1 4450.29,1527.9
X$86758 \$18 \$1149 \$1884 VSS INVR04
* cell instance $86760 r0 *1 4480.3,1527.9
X$86760 \$18 \$1951 \$1952 VSS INVR03
* cell instance $86761 r0 *1 4497.1,1527.9
X$86761 \$18 \$1993 \$1951 VSS INVR02
* cell instance $86770 r0 *1 4568.52,1527.9
X$86770 \$18 \$1576 \$1941 VSS INVR02
* cell instance $86771 m90 *1 4608.1,1527.9
X$86771 \$1956 \$1995 \$18 \$1955 VSS OR2101
* cell instance $86776 r0 *1 4620.01,1527.9
X$86776 \$18 \$1578 \$1996 VSS INVR02
* cell instance $86777 r0 *1 4636.81,1527.9
X$86777 \$1691 \$18 \$1834 VSS INVR01
* cell instance $86781 r0 *1 4665.36,1527.9
X$86781 \$1941 \$1998 \$1999 \$1660 \$1847 \$18 VSS AND401
* cell instance $86783 r0 *1 4703.17,1527.9
X$86783 \$18 \$2001 \$2002 VSS INVR02
* cell instance $86787 m90 *1 4765.92,1527.9
X$86787 \$18 \$2001 \$2004 \$2005 VSS AND201
* cell instance $86788 r0 *1 4765.92,1527.9
X$86788 \$18 \$1699 \$1746 \$1999 VSS AND201
* cell instance $86790 m90 *1 4813.64,1527.9
X$86790 \$18 \$1961 \$1959 VSS INVR03
* cell instance $86793 m90 *1 4840.06,1527.9
X$86793 \$1961 \$1698 \$18 \$1962 VSS OR2101
* cell instance $86797 m90 *1 4870.13,1527.9
X$86797 \$18 \$1701 \$1962 VSS INVR03
* cell instance $86800 m90 *1 4891.11,1527.9
X$86800 \$18 \$1963 \$1963 VSS INVR02
* cell instance $86806 r0 *1 4922.02,1527.9
X$86806 \$18 \$1963 \$2010 VSS INVR02
* cell instance $86824 r0 *1 5071.35,1527.9
X$86824 \$18 \$1857 \$1701 VSS INVR03
* cell instance $86839 r0 *1 5241.21,1527.9
X$86839 \$18 \$1859 \$2013 VSS INVR02
* cell instance $86847 r0 *1 5310.5,1527.9
X$86847 \$18 \$2013 \$1719 VSS INVR03
* cell instance $86854 r0 *1 5372.61,1527.9
X$86854 \$1470 \$18 \$1968 VSS INVR05
* cell instance $87293 r0 *1 3973.62,1173.1
X$87293 \$18 \$1394 \$1434 VSS INVR02
* cell instance $87298 r0 *1 4107.61,1173.1
X$87298 \$18 \$194 \$1436 VSS INVR03
* cell instance $87305 r0 *1 4229.42,1173.1
X$87305 \$18 \$40 \$1140 VSS INVR03
* cell instance $87307 r0 *1 4246.22,1173.1
X$87307 \$1113 \$18 \$1145 VSS INVR05
* cell instance $87308 r0 *1 4271.83,1173.1
X$87308 \$18 \$1440 \$1284 VSS INVR02
* cell instance $87313 r0 *1 4312.04,1173.1
X$87313 \$18 \$1336 \$1286 VSS INVR02
* cell instance $87316 r0 *1 4331.83,1173.1
X$87316 \$18 \$1441 \$1484 VSS INVR02
* cell instance $87317 r0 *1 4348.63,1173.1
X$87317 \$18 \$1484 \$1400 VSS INVR03
* cell instance $87321 r0 *1 4386.12,1173.1
X$87321 \$18 \$1286 \$1442 VSS INVR03
* cell instance $87323 r0 *1 4406.01,1173.1
X$87323 \$18 \$1384 \$1288 VSS INVR02
* cell instance $87326 r0 *1 4431,1173.1
X$87326 \$18 \$1443 \$1289 VSS INVR03
* cell instance $87328 r0 *1 4450.27,1173.1
X$87328 \$18 \$1502 \$1445 VSS INVR02
* cell instance $87329 r0 *1 4467.07,1173.1
X$87329 \$18 \$1338 \$1241 VSS INVR02
* cell instance $87330 r0 *1 4483.87,1173.1
X$87330 \$18 \$1445 \$1368 VSS INVR03
* cell instance $87331 r0 *1 4500.67,1173.1
X$87331 \$18 \$1296 \$1384 VSS INVR02
* cell instance $87333 r0 *1 4520.01,1173.1
X$87333 \$1446 \$18 \$1368 VSS INVR05
* cell instance $87335 m90 *1 4570.42,1173.1
X$87335 \$18 \$1448 \$1447 VSS INVR02
* cell instance $87339 r0 *1 4590.62,1173.1
X$87339 \$18 \$1442 \$1450 VSS INVR02
* cell instance $87342 r0 *1 4615.18,1173.1
X$87342 \$18 \$1290 \$1298 VSS INVR03
* cell instance $87351 r0 *1 4682.56,1173.1
X$87351 \$18 \$1300 \$1451 VSS INVR02
* cell instance $87354 r0 *1 4713.16,1173.1
X$87354 \$1452 \$18 \$1505 VSS INVR01
* cell instance $87356 r0 *1 4725.76,1173.1
X$87356 \$18 \$1412 \$1454 VSS INVR02
* cell instance $87357 m90 *1 4777.29,1173.1
X$87357 \$1387 \$18 \$1537 \$1455 VSS NOR201
* cell instance $87359 r0 *1 4777.29,1173.1
X$87359 \$1297 \$1456 \$1149 \$1300 \$1458 \$1368 \$18 VSS AND501
* cell instance $87362 r0 *1 4830.01,1173.1
X$87362 \$1412 \$18 \$1452 \$1387 VSS NOR201
* cell instance $87363 r0 *1 4863.61,1173.1
X$87363 \$18 \$1454 \$1048 VSS INVR03
* cell instance $87364 r0 *1 4880.42,1173.1
X$87364 \$1304 \$1053 \$1302 \$18 VSS NND201
* cell instance $87365 r0 *1 4981.22,1173.1
X$87365 \$18 \$1054 \$1055 VSS INVR02
* cell instance $87368 r0 *1 5010.18,1173.1
X$87368 \$18 \$1057 \$1417 VSS INVR02
* cell instance $87371 r0 *1 5038.09,1173.1
X$87371 \$1249 \$1467 \$1418 \$18 VSS XNR201
* cell instance $87375 r0 *1 5082.35,1173.1
X$87375 \$18 \$1468 \$1310 \$1418 VSS AND201
* cell instance $87378 m90 *1 5135.57,1173.1
X$87378 \$18 \$1420 \$1165 VSS INVR02
* cell instance $87381 r0 *1 5137.56,1173.1
X$87381 \$1420 \$18 \$1470 \$1471 VSS NOR201
* cell instance $87384 r0 *1 5180.69,1173.1
X$87384 \$1475 \$18 \$1468 \$1474 VSS NOR201
* cell instance $87389 r0 *1 5247.03,1173.1
X$87389 \$18 \$1475 \$1376 VSS INVR03
* cell instance $87390 r0 *1 5263.83,1173.1
X$87390 \$18 \$1476 \$1422 VSS INVR03
* cell instance $87394 r0 *1 5392.58,1173.1
X$87394 \$18 \$1424 \$1425 VSS INVR03
* cell instance $87404 r0 *1 5470.89,1173.1
X$87404 \$18 \$1249 \$1425 VSS INVR06
* cell instance $87407 r0 *1 5513.1,1173.1
X$87407 \$18 \$1479 \$1249 VSS INVR06
* cell instance $87826 r0 *1 3904.2,1705.3
X$87826 \$18 \$2256 \$2174 VSS INVR03
* cell instance $87831 m90 *1 3970.23,1705.3
X$87831 \$18 \$842 \$2258 VSS INVR02
* cell instance $87832 r0 *1 3970.23,1705.3
X$87832 \$18 \$2121 \$2256 VSS INVR02
* cell instance $87836 r0 *1 4048.48,1705.3
X$87836 \$18 \$2174 \$2122 VSS INVR03
* cell instance $87837 r0 *1 4065.95,1705.3
X$87837 \$18 \$2127 \$2128 VSS INVR03
* cell instance $87841 m90 *1 4168.96,1705.3
X$87841 \$18 \$2261 \$2125 \$2263 VSS AND201
* cell instance $87842 r0 *1 4168.96,1705.3
X$87842 \$2231 \$18 \$2132 \$2130 VSS NOR201
* cell instance $87843 m90 *1 4240.36,1705.3
X$87843 \$2268 \$2135 \$2263 \$18 VSS XNR201
* cell instance $87846 m90 *1 4269.4,1705.3
X$87846 \$18 \$2132 \$1982 VSS INVR02
* cell instance $87848 r0 *1 4275,1705.3
X$87848 \$18 \$2130 \$2225 VSS INVR03
* cell instance $87850 m90 *1 4312.8,1705.3
X$87850 \$2072 \$2268 \$18 \$1993 VSS OR2101
* cell instance $87852 r0 *1 4368.19,1705.3
X$87852 \$18 \$2271 \$2272 VSS INVR02
* cell instance $87855 r0 *1 4398.19,1705.3
X$87855 \$18 \$2125 \$2228 VSS INVR03
* cell instance $87860 r0 *1 4435.81,1705.3
X$87860 \$18 \$2274 \$2133 VSS INVR02
* cell instance $87861 m90 *1 4473.61,1705.3
X$87861 \$2231 \$2274 \$18 \$2210 VSS OR2101
* cell instance $87865 r0 *1 4489.44,1705.3
X$87865 \$2276 \$18 \$2275 VSS INVR01
* cell instance $87867 r0 *1 4502.04,1705.3
X$87867 \$2187 \$18 \$1996 VSS INVR01
* cell instance $87868 r0 *1 4514.64,1705.3
X$87868 \$18 \$1832 \$2145 VSS INVR02
* cell instance $87869 m90 *1 4586.05,1705.3
X$87869 \$1955 \$1956 \$1611 \$2232 \$2277 \$2363 \$2276 \$18 VSS NOR601
* cell instance $87872 r0 *1 4592.95,1705.3
X$87872 \$18 \$1578 \$2148 VSS INVR02
* cell instance $87877 r0 *1 4636.71,1705.3
X$87877 \$18 \$1995 \$1578 VSS INVR02
* cell instance $87878 r0 *1 4653.51,1705.3
X$87878 \$18 \$1834 \$1956 VSS INVR03
* cell instance $87879 m90 *1 4687.11,1705.3
X$87879 \$18 \$1999 \$1839 VSS INVR02
* cell instance $87884 r0 *1 4719.72,1705.3
X$87884 \$18 \$1693 \$2326 VSS INVR02
* cell instance $87885 r0 *1 4736.52,1705.3
X$87885 \$18 \$2282 \$2283 VSS INVR02
* cell instance $87886 m90 *1 4770.12,1705.3
X$87886 \$18 \$2284 \$2154 VSS INVR02
* cell instance $87887 r0 *1 4770.12,1705.3
X$87887 \$18 \$2283 \$2156 VSS INVR02
* cell instance $87889 r0 *1 4790.21,1705.3
X$87889 \$18 \$2309 \$2312 VSS INVR02
* cell instance $87891 r0 *1 4807.01,1705.3
X$87891 \$18 \$2312 \$1961 VSS INVR03
* cell instance $87894 r0 *1 4835.92,1705.3
X$87894 \$2156 \$2288 \$2308 \$18 VSS XNR201
* cell instance $87896 r0 *1 4878.68,1705.3
X$87896 \$2306 \$18 \$2308 \$2004 VSS NOR201
* cell instance $87899 r0 *1 4971.63,1705.3
X$87899 \$18 \$2160 \$2245 VSS INVR03
* cell instance $87901 r0 *1 5092.07,1705.3
X$87901 \$18 \$2098 \$2374 VSS INVR06
* cell instance $87914 r0 *1 5218.36,1705.3
X$87914 \$18 \$2164 \$2166 VSS INVR02
* cell instance $87931 r0 *1 5359.2,1705.3
X$87931 \$18 \$1968 \$2252 VSS INVR02
* cell instance $87936 r0 *1 5391.44,1705.3
X$87936 \$18 \$2295 \$2252 VSS INVR06
* cell instance $87957 r0 *1 5570.85,1705.3
X$87957 \$18 \$2296 \$1869 VSS INVR06
* cell instance $88370 r0 *1 1472.69,2060.1
X$88370 \$18 \$2767 \$2768 VSS INVR06
* cell instance $88407 r0 *1 1791,2060.1
X$88407 \$18 \$2685 \$2835 \$2834 VSS AND201
* cell instance $88410 r0 *1 1834.2,2060.1
X$88410 \$18 \$2634 \$2771 VSS INVR03
* cell instance $88420 r0 *1 1915.81,2060.1
X$88420 \$2836 \$18 \$2772 VSS INVR05
* cell instance $88471 r0 *1 2335.8,2060.1
X$88471 \$18 \$3077 \$2830 VSS INVR03
* cell instance $88474 r0 *1 2358.9,2060.1
X$88474 \$18 \$2838 \$2830 VSS INVR06
* cell instance $88653 m90 *1 3832.33,2060.1
X$88653 \$18 \$2839 \$2686 VSS INVR06
* cell instance $88655 r0 *1 3837.14,2060.1
X$88655 \$18 \$2775 \$1128 \$2551 VSS AND201
* cell instance $88666 r0 *1 3925.47,2060.1
X$88666 \$18 \$2840 \$2775 VSS INVR06
* cell instance $88668 r0 *1 3964.36,2060.1
X$88668 \$18 \$2842 \$2258 \$2551 VSS AND201
* cell instance $88671 r0 *1 3991.72,2060.1
X$88671 \$18 \$2638 \$2779 VSS INVR06
* cell instance $88674 r0 *1 4027.43,2060.1
X$88674 \$2843 \$18 \$2638 VSS INVR05
* cell instance $88676 m90 *1 4086.22,2060.1
X$88676 \$18 \$2781 \$2695 \$2551 VSS AND201
* cell instance $88678 r0 *1 4091.02,2060.1
X$88678 \$2844 \$18 \$2784 VSS INVR05
* cell instance $88680 m90 *1 4145.3,2060.1
X$88680 \$18 \$2845 \$2747 VSS INVR04
* cell instance $88684 m90 *1 4180.81,2060.1
X$88684 \$18 \$2845 \$2551 VSS INVR03
* cell instance $88690 m90 *1 4238.66,2060.1
X$88690 \$18 \$2846 \$2747 VSS INVR03
* cell instance $88694 r0 *1 4250.52,2060.1
X$88694 \$18 \$2850 \$2788 VSS INVR03
* cell instance $88699 m90 *1 4298.67,2060.1
X$88699 \$18 \$2852 \$2851 VSS INVR02
* cell instance $88700 r0 *1 4298.67,2060.1
X$88700 \$2790 \$18 \$2789 VSS INVR01
* cell instance $88705 r0 *1 4336.37,2060.1
X$88705 \$18 \$2524 \$2788 VSS INVR06
* cell instance $88706 r0 *1 4365.77,2060.1
X$88706 \$18 \$2228 \$2656 VSS INVR03
* cell instance $88707 r0 *1 4382.57,2060.1
X$88707 \$18 \$2517 \$2415 VSS INVR02
* cell instance $88710 r0 *1 4405.94,2060.1
X$88710 \$2765 \$2800 \$18 \$2524 VSS OR2101
* cell instance $88717 m90 *1 4492.98,2060.1
X$88717 \$18 \$2651 \$2410 VSS INVR03
* cell instance $88719 r0 *1 4492.98,2060.1
X$88719 \$2856 \$18 \$2855 VSS INVR01
* cell instance $88720 r0 *1 4506.18,2060.1
X$88720 \$18 \$2800 \$2889 VSS INVR02
* cell instance $88721 r0 *1 4522.98,2060.1
X$88721 \$18 \$2889 \$2857 VSS INVR02
* cell instance $88723 m90 *1 4567.96,2060.1
X$88723 \$18 \$2652 \$2701 \$2858 VSS AND201
* cell instance $88724 r0 *1 4567.96,2060.1
X$88724 \$18 \$2858 \$2859 VSS INVR02
* cell instance $88725 m90 *1 4601.56,2060.1
X$88725 \$18 \$2562 \$2765 VSS INVR03
* cell instance $88729 r0 *1 4617.08,2060.1
X$88729 \$18 \$2860 \$2861 VSS INVR02
* cell instance $88733 m90 *1 4764.01,2060.1
X$88733 \$2863 \$18 \$2701 \$2558 VSS NOR201
* cell instance $88735 r0 *1 4768.82,2060.1
X$88735 \$18 \$2865 \$2864 \$2754 VSS AND201
* cell instance $88737 r0 *1 4803.02,2060.1
X$88737 \$2807 \$2864 \$18 \$2808 VSS OR2101
* cell instance $88740 r0 *1 4870.85,2060.1
X$88740 \$18 \$2631 \$2446 VSS INVR02
* cell instance $88743 r0 *1 4897.2,2060.1
X$88743 \$18 \$2754 \$2885 VSS INVR02
* cell instance $88745 r0 *1 4914.78,2060.1
X$88745 \$18 \$2885 \$2710 VSS INVR02
* cell instance $88746 r0 *1 4931.59,2060.1
X$88746 \$18 \$2867 \$2816 VSS INVR06
* cell instance $88747 r0 *1 4960.99,2060.1
X$88747 \$18 \$2868 \$2564 VSS INVR03
* cell instance $88750 r0 *1 4988.18,2060.1
X$88750 \$2710 \$2820 \$18 \$2715 VSS OR2101
* cell instance $88751 r0 *1 5093.19,2060.1
X$88751 \$18 \$2712 \$2543 VSS INVR03
* cell instance $88755 r0 *1 5123.19,2060.1
X$88755 \$18 \$1236 \$2669 VSS INVR06
* cell instance $88758 r0 *1 5162.52,2060.1
X$88758 \$18 \$2873 \$2823 VSS INVR02
* cell instance $88759 r0 *1 5179.32,2060.1
X$88759 \$18 \$2824 \$2873 VSS INVR02
* cell instance $88762 r0 *1 5203.47,2060.1
X$88762 \$2715 \$2441 \$2660 \$18 VSS NND201
* cell instance $88845 r0 *1 5859.66,2060.1
X$88845 \$18 \$2672 \$2719 VSS INVR03
* cell instance $89224 m90 *1 3831,1882.7
X$89224 \$18 \$2546 \$2504 VSS INVR03
* cell instance $89226 m90 *1 3870.06,1882.7
X$89226 \$18 \$2511 \$2504 VSS INVR06
* cell instance $89229 m90 *1 3900.07,1882.7
X$89229 \$18 \$2546 \$1135 \$2489 VSS AND201
* cell instance $89233 r0 *1 3914.4,1882.7
X$89233 \$18 \$1037 \$1819 \$2489 VSS AND201
* cell instance $89239 m90 *1 3996.03,1882.7
X$89239 \$18 \$2550 \$1727 \$2551 VSS AND201
* cell instance $89242 r0 *1 4004.19,1882.7
X$89242 \$18 \$1037 \$2577 VSS INVR02
* cell instance $89243 r0 *1 4023.09,1882.7
X$89243 \$18 \$2577 \$2515 VSS INVR03
* cell instance $89254 r0 *1 4099.9,1882.7
X$89254 \$18 \$611 \$2553 VSS INVR02
* cell instance $89263 r0 *1 4308.86,1882.7
X$89263 \$18 \$2553 \$2555 VSS INVR03
* cell instance $89271 r0 *1 4429.14,1882.7
X$89271 \$18 \$2210 \$2077 VSS INVR03
* cell instance $89289 r0 *1 4573.5,1882.7
X$89289 \$18 \$2364 \$2135 VSS INVR02
* cell instance $89293 r0 *1 4603.5,1882.7
X$89293 \$18 \$2363 \$2495 VSS INVR02
* cell instance $89295 r0 *1 4620.9,1882.7
X$89295 \$18 \$2557 \$2523 VSS INVR06
* cell instance $89296 r0 *1 4650.3,1882.7
X$89296 \$18 \$2495 \$2593 VSS INVR02
* cell instance $89297 r0 *1 4667.11,1882.7
X$89297 \$18 \$2524 \$1693 VSS INVR03
* cell instance $89298 r0 *1 4683.91,1882.7
X$89298 \$18 \$2593 \$2558 VSS INVR03
* cell instance $89300 m90 *1 4737.45,1882.7
X$89300 \$2430 \$18 \$2497 \$2559 VSS NOR201
* cell instance $89302 r0 *1 4737.46,1882.7
X$89302 \$18 \$2431 \$2429 VSS INVR02
* cell instance $89307 m90 *1 4797.46,1882.7
X$89307 \$18 \$2528 \$2560 VSS INVR02
* cell instance $89309 m90 *1 4822.96,1882.7
X$89309 \$18 \$2563 \$2562 VSS INVR02
* cell instance $89310 r0 *1 4822.96,1882.7
X$89310 \$18 \$2564 \$2529 VSS INVR03
* cell instance $89311 r0 *1 4839.76,1882.7
X$89311 \$18 \$2566 \$2497 VSS INVR02
* cell instance $89312 r0 *1 4857.16,1882.7
X$89312 \$18 \$1139 \$2500 VSS INVR06
* cell instance $89313 m90 *1 4941.16,1882.7
X$89313 \$2005 \$2188 \$1844 \$2496 \$2282 \$2148 \$2429 \$18 VSS NOR601
* cell instance $89314 r0 *1 4941.16,1882.7
X$89314 \$18 \$2570 \$2500 VSS INVR03
* cell instance $89315 m90 *1 4974.76,1882.7
X$89315 \$18 \$1963 \$2288 VSS INVR03
* cell instance $89318 r0 *1 5088.05,1882.7
X$89318 \$18 \$2541 \$2443 VSS INVR02
* cell instance $89319 r0 *1 5104.85,1882.7
X$89319 \$18 \$2573 \$2543 VSS INVR06
* cell instance $89789 r0 *1 4145.4,8623.9
X$89789 \$18 \$20358 \$20664 VSS INVR02
* cell instance $89794 r0 *1 4192.3,8623.9
X$89794 \$18 \$20664 \$20628 VSS INVR03
* cell instance $89799 r0 *1 4229.7,8623.9
X$89799 \$18 \$20535 \$20667 VSS INVR02
* cell instance $89802 r0 *1 4252.21,8623.9
X$89802 \$18 \$20532 \$20667 VSS INVR06
* cell instance $89810 m90 *1 4362.05,8623.9
X$89810 \$20536 \$18 \$20627 \$20670 VSS NOR201
* cell instance $89813 m90 *1 4393.81,8623.9
X$89813 \$18 \$20670 \$20628 \$20397 VSS AND201
* cell instance $89816 r0 *1 4401.49,8623.9
X$89816 \$18 \$20537 \$20674 VSS INVR02
* cell instance $89819 r0 *1 4424.02,8623.9
X$89819 \$20628 \$20675 \$20542 \$18 VSS XNR201
* cell instance $89822 m90 *1 4502.41,8623.9
X$89822 \$20675 \$18 \$20716 \$20631 \$20364 VSS NND301
* cell instance $89824 m90 *1 4530.33,8623.9
X$89824 \$18 \$20364 \$20364 \$20631 VSS AND201
* cell instance $89825 r0 *1 4530.33,8623.9
X$89825 \$18 \$20545 \$20548 VSS INVR02
* cell instance $89827 r0 *1 4549.67,8623.9
X$89827 \$18 \$20364 \$20717 VSS INVR02
* cell instance $89828 m90 *1 4587.47,8623.9
X$89828 \$20631 \$20547 \$18 \$20634 VSS OR2101
* cell instance $89829 r0 *1 4587.47,8623.9
X$89829 \$20718 \$18 \$20636 VSS INVR01
* cell instance $89830 m90 *1 4617.15,8623.9
X$89830 \$18 \$20637 \$20631 VSS INVR02
* cell instance $89831 m90 *1 4633.95,8623.9
X$89831 \$18 \$20413 \$20638 VSS INVR03
* cell instance $89832 m90 *1 4680.15,8623.9
X$89832 \$20718 \$20497 \$20415 \$20637 \$20642 \$18 VSS NND401
* cell instance $89833 r0 *1 4680.15,8623.9
X$89833 \$18 \$20683 \$20550 VSS INVR02
* cell instance $89834 r0 *1 4696.95,8623.9
X$89834 \$18 \$20727 \$20600 VSS INVR02
* cell instance $89835 r0 *1 4714.87,8623.9
X$89835 \$18 \$20600 \$20642 VSS INVR03
* cell instance $89837 m90 *1 4748.47,8623.9
X$89837 \$18 \$20456 \$20727 VSS INVR02
* cell instance $89838 r0 *1 4748.47,8623.9
X$89838 \$20723 \$18 \$20565 VSS INVR01
* cell instance $89840 r0 *1 4763.59,8623.9
X$89840 \$18 \$20416 \$20650 VSS INVR02
* cell instance $89843 r0 *1 4783.76,8623.9
X$89843 \$20777 \$18 \$20456 \$20413 VSS NOR201
* cell instance $89844 r0 *1 4817.36,8623.9
X$89844 \$18 \$20777 \$20418 VSS INVR02
* cell instance $89845 r0 *1 4834.16,8623.9
X$89845 \$18 \$20687 \$20554 VSS INVR02
* cell instance $89846 r0 *1 4850.96,8623.9
X$89846 \$20642 \$20559 \$18 \$20230 VSS OR2101
* cell instance $89849 m90 *1 4901.96,8623.9
X$89849 \$18 \$20644 \$20304 VSS INVR03
* cell instance $89851 m90 *1 5002.76,8623.9
X$89851 \$8743 \$19956 \$20025 \$I331476 \$20375 \$18 VSS DFCL11
* cell instance $89854 r0 *1 5008.87,8623.9
X$89854 \$18 \$20256 \$20693 VSS INVR06
* cell instance $89855 r0 *1 5038.27,8623.9
X$89855 \$18 \$20599 \$20687 VSS INVR02
* cell instance $89856 r0 *1 5055.07,8623.9
X$89856 \$18 \$20650 \$20787 VSS INVR02
* cell instance $89859 r0 *1 5079.36,8623.9
X$89859 \$18 \$20787 \$20697 VSS INVR02
* cell instance $89862 m90 *1 5117.81,8623.9
X$89862 \$18 \$20173 \$20232 VSS INVR03
* cell instance $89863 r0 *1 5117.81,8623.9
X$89863 \$18 \$20747 \$20145 VSS INVR02
* cell instance $89864 r0 *1 5134.61,8623.9
X$89864 \$18 \$20609 \$20747 VSS INVR02
* cell instance $89865 m90 *1 5168.21,8623.9
X$89865 \$18 \$8743 \$20644 VSS INVR02
* cell instance $89868 r0 *1 5181.65,8623.9
X$89868 \$18 \$20697 \$20702 VSS INVR03
* cell instance $89873 r0 *1 5219.01,8623.9
X$89873 \$18 \$20612 \$20703 VSS INVR04
* cell instance $89874 m90 *1 5256.81,8623.9
X$89874 \$18 \$20203 \$20751 VSS INVR02
* cell instance $89875 m90 *1 5273.62,8623.9
X$89875 \$18 \$20751 \$20703 VSS INVR02
* cell instance $90817 m90 *1 3950.4,7559.5
X$90817 \$18 \$19962 \$10663 VSS INVR06
* cell instance $90928 r0 *1 4821.05,7559.5
X$90928 \$18 \$19965 \$19954 VSS INVR06
* cell instance $90933 r0 *1 4883.1,7559.5
X$90933 \$18 \$19964 \$19955 VSS INVR03
* cell instance $91434 r0 *1 4961.38,7204.7
X$91434 \$19932 \$18 \$19775 VSS INVR05
* cell instance $91923 r0 *1 4112.47,7382.1
X$91923 \$18 \$19938 \$19407 VSS INVR06
* cell instance $91937 r0 *1 4229.4,7382.1
X$91937 \$18 \$19939 \$19409 VSS INVR06
* cell instance $91952 m90 *1 4401.63,7382.1
X$91952 \$18 \$19940 \$19410 VSS INVR06
* cell instance $92054 r0 *1 5203.53,7382.1
X$92054 \$18 \$19942 \$19944 VSS INVR03
* cell instance $92057 r0 *1 5222.43,7382.1
X$92057 \$18 \$19943 \$19944 VSS INVR06
* cell instance $92514 r0 *1 4853.1,7914.3
X$92514 \$18 \$20022 \$19977 VSS INVR02
* cell instance $92532 m90 *1 5014.26,7914.3
X$92532 \$18 \$19988 \$20025 VSS INVR03
* cell instance $92540 m90 *1 5084.24,7914.3
X$92540 \$18 \$19989 \$20005 \$19862 VSS AND201
* cell instance $92543 r0 *1 5100.45,7914.3
X$92543 \$18 \$20008 \$20007 \$20006 VSS AND201
* cell instance $92545 r0 *1 5127.84,7914.3
X$92545 \$18 \$19893 \$19992 VSS INVR03
* cell instance $92546 m90 *1 5169.84,7914.3
X$92546 \$18 \$20010 \$20005 \$20012 VSS AND201
* cell instance $92547 r0 *1 5169.84,7914.3
X$92547 \$18 \$19981 \$20012 VSS INVR02
* cell instance $93011 m90 *1 5086.98,7027.3
X$93011 \$18 \$19918 \$19919 VSS INVR06
* cell instance $93049 r0 *1 5384.4,7027.3
X$93049 \$19919 \$18 \$18146 VSS INVR05
* cell instance $93487 r0 *1 4174.2,8446.5
X$93487 \$18 \$20115 \$20280 VSS INVR02
* cell instance $93488 m90 *1 4291.8,8446.5
X$93488 \$8743 \$20318 \$20360 \$I331484 \$20358 \$18 VSS DFCL11
* cell instance $93494 m90 *1 4344.36,8446.5
X$93494 \$18 \$20396 \$20118 VSS INVR03
* cell instance $93497 r0 *1 4349.66,8446.5
X$93497 \$18 \$20437 \$20397 VSS INVR02
* cell instance $93499 m90 *1 4400.06,8446.5
X$93499 \$20396 \$18 \$20440 \$20361 VSS NOR201
* cell instance $93502 m90 *1 4432.24,8446.5
X$93502 \$18 \$20440 \$20400 \$20362 VSS AND201
* cell instance $93503 r0 *1 4432.24,8446.5
X$93503 \$20402 \$18 \$20401 VSS INVR01
* cell instance $93504 r0 *1 4444.84,8446.5
X$93504 \$20401 \$18 \$20288 VSS INVR01
* cell instance $93505 r0 *1 4457.44,8446.5
X$93505 \$18 \$20185 \$20364 VSS INVR03
* cell instance $93508 m90 *1 4502.08,8446.5
X$93508 \$18 \$20406 \$20287 VSS INVR02
* cell instance $93511 m90 *1 4528.05,8446.5
X$93511 \$18 \$20407 \$20290 VSS INVR02
* cell instance $93514 m90 *1 4553.31,8446.5
X$93514 \$18 \$20366 \$20400 VSS INVR02
* cell instance $93515 m90 *1 4570.94,8446.5
X$93515 \$18 \$20288 \$20366 VSS INVR03
* cell instance $93517 r0 *1 4576.7,8446.5
X$93517 \$18 \$20189 \$20493 VSS INVR03
* cell instance $93522 m90 *1 4646.54,8446.5
X$93522 \$20290 \$20411 \$20410 \$18 VSS XNR201
* cell instance $93525 m90 *1 4676.55,8446.5
X$93525 \$20456 \$20370 \$18 \$20455 VSS OR2101
* cell instance $93527 m90 *1 4706.56,8446.5
X$93527 \$20163 \$20498 \$18 \$20413 VSS OR2101
* cell instance $93529 r0 *1 4711.36,8446.5
X$93529 \$18 \$20251 \$20300 \$20324 VSS AND201
* cell instance $93530 m90 *1 4753.36,8446.5
X$93530 \$18 \$20460 \$20415 VSS INVR03
* cell instance $93531 m90 *1 4770.16,8446.5
X$93531 \$20323 \$20370 \$20494 \$18 VSS NND201
* cell instance $93533 r0 *1 4774.88,8446.5
X$93533 \$18 \$20195 \$20416 VSS INVR02
* cell instance $93534 m90 *1 4816.88,8446.5
X$93534 \$18 \$20326 \$20300 \$20417 VSS AND201
* cell instance $93537 r0 *1 4823.8,8446.5
X$93537 \$20418 \$20420 \$20417 \$18 VSS XNR201
* cell instance $93539 m90 *1 4891.61,8446.5
X$93539 \$18 \$20291 \$20420 \$20165 VSS AND201
* cell instance $93540 r0 *1 4892.21,8446.5
X$93540 \$18 \$20022 \$20375 VSS INVR06
* cell instance $93541 m90 *1 4938.41,8446.5
X$93541 \$18 \$20259 \$20165 VSS INVR02
* cell instance $93544 r0 *1 4951.61,8446.5
X$93544 \$18 \$19956 \$20113 VSS INVR02
* cell instance $93547 m90 *1 5039.81,8446.5
X$93547 \$18 \$20380 \$20467 VSS INVR02
* cell instance $93548 m90 *1 5056.61,8446.5
X$93548 \$18 \$20205 \$20380 VSS INVR02
* cell instance $93551 r0 *1 5068.8,8446.5
X$93551 \$20300 \$20569 \$20426 \$20383 \$20130 \$18 VSS AOI401
* cell instance $93552 r0 *1 5115.61,8446.5
X$93552 \$18 \$20427 \$20384 VSS INVR06
* cell instance $93553 r0 *1 5145.01,8446.5
X$93553 \$18 \$20426 \$20429 VSS INVR02
* cell instance $93556 r0 *1 5178.85,8446.5
X$93556 \$8743 \$20059 \$20202 \$I331349 \$20132 \$18 VSS DFCL11
* cell instance $94011 r0 *1 4294.2,8269.1
X$94011 \$18 \$20210 \$20104 VSS INVR02
* cell instance $94017 r0 *1 4346.77,8269.1
X$94017 \$18 \$19940 \$20116 VSS INVR02
* cell instance $94022 m90 *1 4412.38,8269.1
X$94022 \$20156 \$18 \$20158 \$20157 VSS NOR201
* cell instance $94026 r0 *1 4423.73,8269.1
X$94026 \$18 \$20184 \$20185 VSS INVR02
* cell instance $94030 r0 *1 4447.81,8269.1
X$94030 \$8743 \$20186 \$20159 \$I331336 \$20160 \$18 VSS DFCL11
* cell instance $94032 r0 *1 4548.61,8269.1
X$94032 \$18 \$20160 \$20119 VSS INVR02
* cell instance $94038 r0 *1 4596.95,8269.1
X$94038 \$18 \$20108 \$20189 VSS INVR03
* cell instance $94055 m90 *1 4745.42,8269.1
X$94055 \$18 \$20190 \$20123 VSS INVR03
* cell instance $94059 r0 *1 4760.91,8269.1
X$94059 \$18 \$20191 \$20192 VSS INVR02
* cell instance $94062 m90 *1 4797.74,8269.1
X$94062 \$18 \$20192 \$19965 VSS INVR02
* cell instance $94064 r0 *1 4797.74,8269.1
X$94064 \$18 \$20127 \$20128 VSS INVR03
* cell instance $94066 r0 *1 4817.65,8269.1
X$94066 \$20194 \$20256 \$20195 \$20145 \$20165 \$18 VSS AOI401
* cell instance $94072 r0 *1 4879.22,8269.1
X$94072 \$18 \$20196 \$20166 VSS INVR06
* cell instance $94073 r0 *1 4908.62,8269.1
X$94073 \$18 \$20130 \$20166 VSS INVR02
* cell instance $94074 m90 *1 4942.22,8269.1
X$94074 \$18 \$20130 \$20259 VSS INVR02
* cell instance $94078 r0 *1 4964.36,8269.1
X$94078 \$18 \$20198 \$20168 VSS INVR03
* cell instance $94083 r0 *1 4996.17,8269.1
X$94083 \$20147 \$18 \$20169 \$20200 VSS NOR201
* cell instance $94084 r0 *1 5029.78,8269.1
X$94084 \$18 \$20199 \$20168 VSS INVR06
* cell instance $94086 r0 *1 5061.93,8269.1
X$94086 \$18 \$20147 \$20202 VSS INVR03
* cell instance $94090 r0 *1 5097.71,8269.1
X$94090 \$18 \$20059 \$20173 VSS INVR03
* cell instance $94091 m90 *1 5152.31,8269.1
X$94091 \$20006 \$20205 \$20204 \$18 VSS XNR201
* cell instance $94097 r0 *1 5183.78,8269.1
X$94097 \$20206 \$18 \$20174 VSS INVR01
* cell instance $94099 r0 *1 5196.52,8269.1
X$94099 \$20207 \$18 \$20006 \$20206 VSS NOR201
* cell instance $94558 m90 *1 4516.26,8091.7
X$94558 \$18 \$19940 \$20071 VSS INVR02
* cell instance $94576 m90 *1 4676.61,8091.7
X$94576 \$18 \$19940 \$20074 VSS INVR06
* cell instance $94579 r0 *1 4687.12,8091.7
X$94579 \$18 \$19951 \$19940 VSS INVR06
* cell instance $94581 m90 *1 4738.92,8091.7
X$94581 \$18 \$20074 \$20094 VSS INVR02
* cell instance $94583 m90 *1 4756.33,8091.7
X$94583 \$18 \$20079 \$20074 VSS INVR03
* cell instance $94587 r0 *1 4782.13,8091.7
X$94587 \$18 \$20038 \$20059 VSS INVR03
* cell instance $94594 r0 *1 4833.74,8091.7
X$94594 \$19969 \$18 \$20060 VSS INVR05
* cell instance $94602 r0 *1 4915.01,8091.7
X$94602 \$18 \$19956 \$20038 VSS INVR02
* cell instance $94621 r0 *1 5066.43,8091.7
X$94621 \$18 \$19862 \$20062 VSS INVR03
* cell instance $94623 r0 *1 5089.14,8091.7
X$94623 \$18 \$20051 \$20063 VSS INVR03
* cell instance $94636 m90 *1 5206.72,8091.7
X$94636 \$18 \$20006 \$20054 VSS INVR04
* cell instance $95703 r0 *1 4851,7736.9
X$95703 \$18 \$19977 \$19978 VSS INVR02
* cell instance $95717 r0 *1 4961.38,7736.9
X$95717 \$18 \$19979 \$19932 VSS INVR06
* cell instance $95758 r0 *1 5304.98,7736.9
X$95758 \$18 \$19981 \$19980 VSS INVR06
* cell instance $95762 m90 *1 5371.62,7736.9
X$95762 \$18 \$19910 \$19982 VSS INVR02
* cell instance $96204 m90 *1 5775.46,6849.9
X$96204 \$19910 \$18 \$19657 VSS INVR05
* cell instance $96596 m90 *1 68.96,4543.7
X$96596 \$18 \$6586 \$12384 VSS INVR02
* cell instance $96597 r0 *1 21.6,4543.7
X$96597 \$18 \$11856 \$11811 VSS INVR06
* cell instance $96601 m90 *1 99.26,4543.7
X$96601 \$18 \$12727 \$3877 VSS INVR02
* cell instance $96603 m90 *1 116.06,4543.7
X$96603 \$18 \$5110 \$12639 VSS INVR02
* cell instance $96607 r0 *1 134.5,4543.7
X$96607 \$18 \$9419 \$12253 VSS INVR02
* cell instance $96608 r0 *1 151.3,4543.7
X$96608 \$12387 \$18 \$12253 VSS INVR05
* cell instance $96613 m90 *1 314.65,4543.7
X$96613 \$18 \$12389 \$12390 \$12391 VSS AND201
* cell instance $96615 m90 *1 339.4,4543.7
X$96615 \$11822 \$12392 \$18 \$9424 VSS OR2101
* cell instance $96619 m90 *1 378.4,4543.7
X$96619 \$12391 \$18 \$12207 VSS INVR05
* cell instance $96623 m90 *1 408.4,4543.7
X$96623 \$18 \$9429 \$12395 VSS INVR02
* cell instance $96625 r0 *1 409.11,4543.7
X$96625 \$18 \$12396 \$11691 VSS INVR02
* cell instance $96628 m90 *1 456.45,4543.7
X$96628 \$18 \$12398 \$11826 VSS INVR02
* cell instance $96630 r0 *1 456.45,4543.7
X$96630 \$12144 \$11827 \$12700 \$18 VSS NND201
* cell instance $96632 m90 *1 503.26,4543.7
X$96632 \$18 \$12398 \$12400 \$11822 VSS AND201
* cell instance $96635 m90 *1 533.26,4543.7
X$96635 \$18 \$11831 \$12207 VSS INVR03
* cell instance $96637 r0 *1 533.26,4543.7
X$96637 \$12404 \$18 \$12402 \$12148 VSS NOR201
* cell instance $96639 m90 *1 587.65,4543.7
X$96639 \$12400 \$12148 \$12263 \$18 VSS NND201
* cell instance $96641 r0 *1 587.65,4543.7
X$96641 \$18 \$12642 \$12418 VSS INVR02
* cell instance $96643 r0 *1 609.09,4543.7
X$96643 \$18 \$12264 \$12149 VSS INVR06
* cell instance $96644 m90 *1 655.29,4543.7
X$96644 \$18 \$8967 \$12149 VSS INVR03
* cell instance $96645 r0 *1 655.29,4543.7
X$96645 \$18 \$12270 \$12264 VSS INVR06
* cell instance $96648 m90 *1 723.5,4543.7
X$96648 \$12268 \$11687 \$18 \$12267 VSS OR2101
* cell instance $96651 r0 *1 732.08,4543.7
X$96651 \$12269 \$3880 \$18 \$10003 \$12268 VSS NOR301
* cell instance $96653 m90 *1 799.21,4543.7
X$96653 \$11851 \$12263 \$18 \$12270 VSS OR2101
* cell instance $96654 m90 *1 925.89,4543.7
X$96654 \$11841 \$18 \$11842 VSS INVR05
* cell instance $96656 r0 *1 927,4543.7
X$96656 \$18 \$12416 \$8176 VSS INVR06
* cell instance $96657 r0 *1 956.4,4543.7
X$96657 \$18 \$12417 \$11841 VSS INVR04
* cell instance $96658 r0 *1 977.4,4543.7
X$96658 \$18 \$12418 \$12419 VSS INVR02
* cell instance $96661 r0 *1 1008.06,4543.7
X$96661 \$18 \$12219 \$10028 \$11143 VSS AND201
* cell instance $96665 r0 *1 1044.84,4543.7
X$96665 \$11141 \$12420 \$18 \$12219 VSS OR2101
* cell instance $96671 r0 *1 1081.68,4543.7
X$96671 \$18 \$12421 \$12276 VSS INVR06
* cell instance $96672 r0 *1 1111.08,4543.7
X$96672 \$18 \$12420 \$11849 VSS INVR02
* cell instance $96673 r0 *1 1127.88,4543.7
X$96673 \$12279 \$18 \$11143 VSS INVR01
* cell instance $96676 r0 *1 1152.78,4543.7
X$96676 \$18 \$12281 \$11851 \$12279 VSS AND201
* cell instance $96680 r0 *1 1192.62,4543.7
X$96680 \$18 \$12281 \$12283 VSS INVR03
* cell instance $96683 r0 *1 1222.63,4543.7
X$96683 \$18 \$11697 \$12423 VSS INVR03
* cell instance $96689 r0 *1 1361.53,4543.7
X$96689 \$18 \$12425 \$12222 VSS INVR06
* cell instance $96695 r0 *1 1426.91,4543.7
X$96695 \$18 \$12426 \$12222 VSS INVR03
* cell instance $96701 r0 *1 1471.65,4543.7
X$96701 \$18 \$12296 \$12290 VSS INVR03
* cell instance $96703 r0 *1 1488.45,4543.7
X$96703 \$18 \$11860 \$11158 VSS INVR02
* cell instance $96707 m90 *1 1551.46,4543.7
X$96707 \$18 \$12430 \$11155 \$7886 VSS AND201
* cell instance $96708 m90 *1 1576.67,4543.7
X$96708 \$18 \$11859 \$11164 \$7886 VSS AND201
* cell instance $96711 r0 *1 1592.7,4543.7
X$96711 \$11706 \$18 \$11356 \$11155 \$11154 VSS AND301
* cell instance $96717 m90 *1 1681.51,4543.7
X$96717 \$18 \$11361 \$11164 \$11870 VSS AND201
* cell instance $96718 r0 *1 1681.56,4543.7
X$96718 \$18 \$11577 \$12296 VSS INVR03
* cell instance $96719 m90 *1 1736.16,4543.7
X$96719 \$11867 \$12037 \$11868 \$11156 \$10603 \$18 VSS AND401
* cell instance $96725 r0 *1 1766.17,4543.7
X$96725 \$18 \$11872 \$11578 VSS INVR02
* cell instance $96736 r0 *1 1856.97,4543.7
X$96736 \$18 \$12290 \$12438 VSS INVR02
* cell instance $96737 r0 *1 1873.77,4543.7
X$96737 \$18 \$10606 \$11577 VSS INVR03
* cell instance $96744 r0 *1 1933.06,4543.7
X$96744 \$18 \$11873 \$12586 VSS INVR02
* cell instance $96745 r0 *1 1949.86,4543.7
X$96745 \$18 \$12586 \$12439 VSS INVR02
* cell instance $96752 m90 *1 2026.66,4543.7
X$96752 \$11020 \$10822 \$11874 \$18 VSS NND201
* cell instance $96766 r0 *1 2112.6,4543.7
X$96766 \$18 \$12443 \$9505 VSS INVR06
* cell instance $96769 r0 *1 2149.17,4543.7
X$96769 \$18 \$10604 \$10613 VSS INVR03
* cell instance $96774 r0 *1 2184.96,4543.7
X$96774 \$18 \$12445 \$10607 \$8942 VSS AND201
* cell instance $96781 m90 *1 2278.6,4543.7
X$96781 \$18 \$11885 \$10617 VSS INVR02
* cell instance $96782 r0 *1 2278.6,4543.7
X$96782 \$12240 \$11719 \$18 \$12308 VSS OR2101
* cell instance $96784 m90 *1 2317.16,4543.7
X$96784 \$12449 \$18 \$12450 VSS INVR01
* cell instance $96785 r0 *1 2317.4,4543.7
X$96785 \$18 \$12451 \$9509 VSS INVR06
* cell instance $96787 r0 *1 2349.36,4543.7
X$96787 \$18 \$9514 \$11887 VSS INVR03
* cell instance $96788 m90 *1 2395.56,4543.7
X$96788 \$18 \$10607 \$12310 VSS INVR06
* cell instance $96791 r0 *1 2451.33,4543.7
X$96791 \$18 \$11193 \$6652 VSS INVR06
* cell instance $96792 r0 *1 2480.73,4543.7
X$96792 \$18 \$11852 \$11378 VSS INVR06
* cell instance $96793 r0 *1 2510.13,4543.7
X$96793 \$18 \$11199 \$11203 VSS INVR06
* cell instance $96794 r0 *1 2539.53,4543.7
X$96794 \$18 \$10231 \$12316 VSS INVR03
* cell instance $96799 m90 *1 2618.08,4543.7
X$96799 \$18 \$11888 \$11896 VSS INVR06
* cell instance $96800 r0 *1 2618.09,4543.7
X$96800 \$18 \$12334 \$12458 VSS INVR02
* cell instance $96805 r0 *1 2658.6,4543.7
X$96805 \$18 \$11887 \$12318 VSS INVR03
* cell instance $96813 r0 *1 2706.9,4543.7
X$96813 \$18 \$12461 \$10629 VSS INVR06
* cell instance $96816 m90 *1 2768.59,4543.7
X$96816 \$12176 \$12462 \$18 \$11193 VSS OR2101
* cell instance $96818 r0 *1 2768.59,4543.7
X$96818 \$12668 \$12462 \$12464 \$12465 \$10630 \$18 VSS AND401
* cell instance $96820 r0 *1 2809.32,4543.7
X$96820 \$18 \$11916 \$7624 VSS INVR06
* cell instance $96824 r0 *1 2853.13,4543.7
X$96824 \$12612 \$18 \$10065 \$11193 VSS NOR201
* cell instance $96825 r0 *1 2886.73,4543.7
X$96825 \$18 \$12612 \$11909 VSS INVR02
* cell instance $96828 m90 *1 2940.54,4543.7
X$96828 \$18 \$9691 \$11923 VSS INVR06
* cell instance $96830 r0 *1 2940.63,4543.7
X$96830 \$12176 \$12469 \$18 \$11900 VSS OR2101
* cell instance $96836 r0 *1 3002.13,4543.7
X$96836 \$18 \$8212 \$11915 VSS INVR03
* cell instance $96838 m90 *1 3091.45,4543.7
X$96838 \$11914 \$12473 \$12469 \$12237 \$12471 \$12474 \$18 VSS AND501
* cell instance $96839 m90 *1 3104.05,4543.7
X$96839 \$12473 \$18 \$11220 VSS INVR01
* cell instance $96840 m90 *1 3120.86,4543.7
X$96840 \$18 \$12477 \$12474 VSS INVR02
* cell instance $96841 r0 *1 3120.86,4543.7
X$96841 \$18 \$12625 \$10654 \$11913 VSS AND201
* cell instance $96842 r0 *1 3146.06,4543.7
X$96842 \$18 \$12625 \$12479 VSS INVR02
* cell instance $96843 r0 *1 3162.86,4543.7
X$96843 \$18 \$12184 \$12480 VSS INVR02
* cell instance $96844 r0 *1 3180.01,4543.7
X$96844 \$18 \$12479 \$12334 VSS INVR03
* cell instance $96846 r0 *1 3251.41,4543.7
X$96846 \$18 \$12483 \$12484 VSS INVR03
* cell instance $96848 r0 *1 3271.06,4543.7
X$96848 \$12337 \$18 \$11923 VSS INVR01
* cell instance $96851 r0 *1 3291.33,4543.7
X$96851 \$11925 \$12338 \$18 \$12337 VSS OR2101
* cell instance $96855 m90 *1 3343.15,4543.7
X$96855 \$12485 \$12187 \$12338 \$18 VSS NND201
* cell instance $96857 r0 *1 3343.15,4543.7
X$96857 \$10648 \$12488 \$18 \$12484 VSS OR2101
* cell instance $96862 r0 *1 3383.38,4543.7
X$96862 \$12490 \$18 \$12484 \$11230 VSS NOR201
* cell instance $96904 r0 *1 3747.01,4543.7
X$96904 \$18 \$11933 \$11232 VSS INVR03
* cell instance $96981 r0 *1 4360.19,4543.7
X$96981 \$18 \$11236 \$11938 VSS INVR02
* cell instance $97020 r0 *1 4677.8,4543.7
X$97020 \$12491 \$18 \$11943 \$11237 VSS NOR201
* cell instance $97024 r0 *1 4733.32,4543.7
X$97024 \$11945 \$18 \$11237 VSS INVR01
* cell instance $97038 r0 *1 4836.29,4543.7
X$97038 \$18 \$10677 \$12344 VSS INVR03
* cell instance $97039 r0 *1 4853.09,4543.7
X$97039 \$18 \$12491 \$11948 VSS INVR02
* cell instance $97043 m90 *1 4929.69,4543.7
X$97043 \$11593 \$11594 \$12493 \$12190 \$12189 \$18 VSS AOI401
* cell instance $97044 r0 *1 4929.69,4543.7
X$97044 \$18 \$12494 \$12348 VSS INVR03
* cell instance $97047 r0 *1 4954.1,4543.7
X$97047 \$11596 \$18 \$12349 VSS INVR05
* cell instance $97051 r0 *1 4985.87,4543.7
X$97051 \$18 \$12498 \$11957 VSS INVR02
* cell instance $97052 r0 *1 5002.67,4543.7
X$97052 \$18 \$12497 \$12498 VSS INVR02
* cell instance $97054 r0 *1 5022.16,4543.7
X$97054 \$18 \$12500 \$12499 \$12190 VSS AND201
* cell instance $97055 r0 *1 5047.36,4543.7
X$97055 \$18 \$11953 \$12190 VSS INVR03
* cell instance $97056 r0 *1 5064.16,4543.7
X$97056 \$18 \$12501 \$11594 VSS INVR03
* cell instance $97057 r0 *1 5081.56,4543.7
X$97057 \$18 \$12502 \$11595 \$10463 VSS AND201
* cell instance $97059 r0 *1 5111.56,4543.7
X$97059 \$18 \$12503 \$12506 VSS INVR02
* cell instance $97064 r0 *1 5158.36,4543.7
X$97064 \$12354 \$18 \$12498 VSS INVR01
* cell instance $97068 m90 *1 5200.57,4543.7
X$97068 \$12508 \$11958 \$12354 \$18 VSS NND201
* cell instance $97078 r0 *1 5266.81,4543.7
X$97078 \$12510 \$18 \$12190 \$12356 VSS NOR201
* cell instance $97079 r0 *1 5300.41,4543.7
X$97079 \$18 \$11958 \$10264 VSS INVR03
* cell instance $97083 r0 *1 5331.97,4543.7
X$97083 \$18 \$11932 \$12356 VSS INVR02
* cell instance $97088 r0 *1 5371.8,4543.7
X$97088 \$12512 \$18 \$11596 VSS INVR05
* cell instance $97095 r0 *1 5428.03,4543.7
X$97095 \$18 \$12513 \$11259 VSS INVR03
* cell instance $97097 r0 *1 5444.83,4543.7
X$97097 \$18 \$12514 \$12359 VSS INVR03
* cell instance $97100 r0 *1 5474.23,4543.7
X$97100 \$18 \$11264 \$12359 VSS INVR06
* cell instance $97101 m90 *1 5521.03,4543.7
X$97101 \$18 \$12512 \$11599 VSS INVR02
* cell instance $97105 r0 *1 5541.14,4543.7
X$97105 \$11600 \$18 \$12512 VSS INVR05
* cell instance $97144 r0 *1 5864.54,4543.7
X$97144 \$18 \$11600 \$10733 VSS INVR03
* cell instance $97152 r0 *1 5927.46,4543.7
X$97152 \$11975 \$18 \$11971 VSS INVR01
* cell instance $97153 m90 *1 5973.66,4543.7
X$97153 \$12518 \$18 \$12521 \$11973 VSS NOR201
* cell instance $97160 m90 *1 6072.14,4543.7
X$97160 \$18 \$12521 \$12524 \$11971 VSS AND201
* cell instance $97162 m90 *1 6175.87,4543.7
X$97162 \$8743 \$12527 \$12365 \$I331498 \$12068 \$18 VSS DFCL11
* cell instance $97168 r0 *1 6206.18,4543.7
X$97168 \$12524 \$12373 \$12367 \$9956 \$11427 \$18 VSS AOI401
* cell instance $97169 m90 *1 6269.79,4543.7
X$97169 \$18 \$12367 \$12368 VSS INVR03
* cell instance $97170 m90 *1 6315.99,4543.7
X$97170 \$10101 \$11425 \$12530 \$10133 \$12204 \$18 VSS AOI401
* cell instance $97171 r0 *1 6315.99,4543.7
X$97171 \$12204 \$18 \$9570 VSS INVR01
* cell instance $97173 r0 *1 6329.59,4543.7
X$97173 \$18 \$12532 \$12373 VSS INVR06
* cell instance $97188 m90 *1 6527.97,4543.7
X$97188 \$18 \$11981 \$11985 \$11290 VSS AND201
* cell instance $97197 r0 *1 6588.47,4543.7
X$97197 \$18 \$12537 \$11294 VSS INVR02
* cell instance $97198 r0 *1 6605.27,4543.7
X$97198 \$8743 \$11294 \$11982 \$I331325 \$11775 \$18 VSS DFCL11
* cell instance $97204 r0 *1 6736.08,4543.7
X$97204 \$18 \$12538 \$12539 VSS INVR02
* cell instance $97212 r0 *1 6805.41,4543.7
X$97212 \$12541 \$18 \$12540 VSS INVR01
* cell instance $97225 r0 *1 6916.08,4543.7
X$97225 \$18 \$12542 \$12376 VSS INVR03
* cell instance $97233 m90 *1 6997.08,4543.7
X$97233 \$12378 \$12543 \$18 \$12377 VSS OR2101
* cell instance $97246 m90 *1 7085.84,4543.7
X$97246 \$18 \$12546 \$12545 VSS INVR02
* cell instance $97294 r0 *1 7456.11,4543.7
X$97294 \$18 \$12547 \$12548 VSS INVR02
* cell instance $97297 r0 *1 7486.5,4543.7
X$97297 \$12379 \$18 \$12532 VSS INVR05
* cell instance $97466 r0 *1 8835.69,4543.7
X$97466 \$18 \$11994 \$12197 VSS INVR02
* cell instance $97470 r0 *1 8867.97,4543.7
X$97470 \$18 \$11991 \$12551 VSS INVR02
* cell instance $97473 r180 *1 40.91,4681.1
X$97473 \$18 \$3877 \$12848 VSS INVR02
* cell instance $97483 m0 *1 109.2,4681.1
X$97483 \$18 \$12639 \$12860 VSS INVR03
* cell instance $97484 m0 *1 126,4681.1
X$97484 \$12850 \$18 \$12387 VSS INVR05
* cell instance $97487 r180 *1 180.04,4681.1
X$97487 \$18 \$12727 \$12852 \$12853 VSS AND201
* cell instance $97490 m0 *1 293.66,4681.1
X$97490 \$18 \$12858 \$12857 \$12392 VSS AND201
* cell instance $97491 m0 *1 318.86,4681.1
X$97491 \$13056 \$9433 \$18 \$12391 VSS OR2101
* cell instance $97492 m0 *1 339.86,4681.1
X$97492 \$18 \$12860 \$12730 VSS INVR03
* cell instance $97496 r180 *1 398.49,4681.1
X$97496 \$18 \$13060 \$12390 VSS INVR02
* cell instance $97498 m0 *1 398.49,4681.1
X$97498 \$13061 \$12700 \$18 \$12793 VSS OR2101
* cell instance $97499 m0 *1 419.5,4681.1
X$97499 \$12793 \$18 \$12027 VSS INVR01
* cell instance $97500 m0 *1 432.9,4681.1
X$97500 \$18 \$12866 \$13062 VSS INVR03
* cell instance $97501 r180 *1 466.5,4681.1
X$97501 \$18 \$12867 \$13063 VSS INVR03
* cell instance $97503 r180 *1 491.92,4681.1
X$97503 \$13065 \$12867 \$18 \$11136 VSS OR2101
* cell instance $97506 m0 *1 502.49,4681.1
X$97506 \$13066 \$12869 \$18 \$13065 VSS OR2101
* cell instance $97508 m0 *1 527.65,4681.1
X$97508 \$18 \$5735 \$13069 VSS INVR06
* cell instance $97509 m0 *1 557.05,4681.1
X$97509 \$13065 \$18 \$11820 VSS INVR05
* cell instance $97510 m0 *1 582.25,4681.1
X$97510 \$9894 \$18 \$12892 VSS INVR05
* cell instance $97511 r180 *1 628.45,4681.1
X$97511 \$13074 \$12871 \$18 \$12404 VSS OR2101
* cell instance $97512 m0 *1 628.46,4681.1
X$97512 \$18 \$12264 \$13075 VSS INVR03
* cell instance $97513 m0 *1 645.26,4681.1
X$97513 \$12267 \$12873 \$18 \$12270 VSS OR2101
* cell instance $97515 m0 *1 675.26,4681.1
X$97515 \$11829 \$12266 \$18 \$13077 VSS OR2101
* cell instance $97518 m0 *1 704.35,4681.1
X$97518 \$12642 \$18 \$12857 \$12876 \$12869 VSS AND301
* cell instance $97519 m0 *1 737.95,4681.1
X$97519 \$18 \$12880 \$11133 \$11841 VSS AND201
* cell instance $97521 m0 *1 767.95,4681.1
X$97521 \$18 \$12269 \$12882 \$12873 VSS AND201
* cell instance $97522 m0 *1 793.75,4681.1
X$97522 \$18 \$6790 \$12886 VSS INVR06
* cell instance $97524 m0 *1 932.2,4681.1
X$97524 \$18 \$12886 \$13082 VSS INVR03
* cell instance $97525 m0 *1 949,4681.1
X$97525 \$18 \$12887 \$11843 VSS INVR02
* cell instance $97532 m0 *1 1146.03,4681.1
X$97532 \$12892 \$18 \$13088 VSS INVR05
* cell instance $97536 r180 *1 1195.91,4681.1
X$97536 \$12893 \$18 \$12283 VSS INVR01
* cell instance $97537 m0 *1 1196.52,4681.1
X$97537 \$18 \$11152 \$12283 VSS INVR06
* cell instance $97547 m0 *1 1292.03,4681.1
X$97547 \$18 \$13089 \$11697 VSS INVR04
* cell instance $97548 m0 *1 1313.03,4681.1
X$97548 \$18 \$12896 \$12897 VSS INVR02
* cell instance $97551 m0 *1 1346.19,4681.1
X$97551 \$18 \$12897 \$12814 VSS INVR02
* cell instance $97555 m0 *1 1377.57,4681.1
X$97555 \$18 \$12815 \$12814 \$11858 VSS AND201
* cell instance $97556 m0 *1 1402.77,4681.1
X$97556 \$18 \$13091 \$13269 VSS INVR02
* cell instance $97558 r180 *1 1445.81,4681.1
X$97558 \$12430 \$12426 \$18 \$12815 VSS OR2101
* cell instance $97566 r180 *1 1515.29,4681.1
X$97566 \$18 \$12903 \$7886 \$11154 VSS AND201
* cell instance $97569 r180 *1 1551.05,4681.1
X$97569 \$18 \$12905 \$11356 \$7886 VSS AND201
* cell instance $97576 r180 *1 1617.14,4681.1
X$97576 \$18 \$12826 \$11356 VSS INVR03
* cell instance $97588 m0 *1 1688.13,4681.1
X$97588 \$18 \$13095 \$13094 VSS INVR06
* cell instance $97589 r180 *1 1734.33,4681.1
X$97589 \$18 \$12908 \$12826 VSS INVR02
* cell instance $97592 m0 *1 1944.34,4681.1
X$97592 \$11161 \$18 \$12438 VSS INVR05
* cell instance $97610 m0 *1 2106.06,4681.1
X$97610 \$18 \$13102 \$12299 \$12916 \$9511 VSS NND300
* cell instance $97621 r180 *1 2219.36,4681.1
X$97621 \$18 \$12919 \$12918 VSS INVR02
* cell instance $97629 r180 *1 2296.19,4681.1
X$97629 \$12919 \$18 \$12922 \$12449 \$12921 VSS AND301
* cell instance $97631 m0 *1 2296.19,4681.1
X$97631 \$12922 \$18 \$13105 VSS INVR01
* cell instance $97634 m0 *1 2314.07,4681.1
X$97634 \$18 \$11916 \$12451 VSS INVR06
* cell instance $97637 m0 *1 2347.46,4681.1
X$97637 \$18 \$11720 \$12924 VSS INVR02
* cell instance $97638 m0 *1 2364.26,4681.1
X$97638 \$13105 \$18 \$12842 VSS INVR01
* cell instance $97639 m0 *1 2376.86,4681.1
X$97639 \$18 \$12924 \$12842 VSS INVR02
* cell instance $97640 m0 *1 2393.66,4681.1
X$97640 \$18 \$12842 \$13109 VSS INVR03
* cell instance $97644 r180 *1 2445.38,4681.1
X$97644 \$18 \$11199 \$11724 VSS INVR02
* cell instance $97645 m0 *1 2445.38,4681.1
X$97645 \$18 \$11375 \$13110 VSS INVR03
* cell instance $97646 m0 *1 2462.18,4681.1
X$97646 \$18 \$10620 \$13111 VSS INVR06
* cell instance $97659 m0 *1 2578.67,4681.1
X$97659 \$18 \$12316 \$11194 VSS INVR03
* cell instance $97662 m0 *1 2601,4681.1
X$97662 \$11201 \$12464 \$11887 \$18 \$11888 VSS OR3101
* cell instance $97664 m0 *1 2630.4,4681.1
X$97664 \$18 \$7572 \$11897 VSS INVR02
* cell instance $97671 m0 *1 2689.85,4681.1
X$97671 \$18 \$12668 \$13110 VSS INVR06
* cell instance $97672 r180 *1 2736.05,4681.1
X$97672 \$18 \$10630 \$12935 VSS INVR02
* cell instance $97677 r180 *1 2772.66,4681.1
X$97677 \$18 \$13116 \$12450 VSS INVR02
* cell instance $97681 r180 *1 2818.2,4681.1
X$97681 \$13119 \$12465 \$18 \$13118 VSS OR2101
* cell instance $97684 r180 *1 2855.22,4681.1
X$97684 \$13122 \$13116 \$18 \$13119 VSS OR2101
* cell instance $97688 r180 *1 2895.4,4681.1
X$97688 \$12310 \$18 \$11913 VSS INVR05
* cell instance $97689 r180 *1 2920.6,4681.1
X$97689 \$18 \$13122 \$13126 \$12324 VSS AND201
* cell instance $97693 m0 *1 2940,4681.1
X$97693 \$18 \$11906 \$13131 VSS INVR02
* cell instance $97697 m0 *1 2968.54,4681.1
X$97697 \$9531 \$13118 \$12941 \$18 VSS PDDR04
* cell instance $97701 m0 *1 3046.08,4681.1
X$97701 \$18 \$12941 \$13136 VSS INVR02
* cell instance $97704 r180 *1 3095.75,4681.1
X$97704 \$13137 \$12237 \$18 \$11913 VSS OR2101
* cell instance $97706 m0 *1 3095.76,4681.1
X$97706 \$10073 \$12943 \$18 \$8457 \$13133 VSS NOR301
* cell instance $97707 m0 *1 3134.8,4681.1
X$97707 \$18 \$12944 \$12477 VSS INVR02
* cell instance $97709 m0 *1 3151.6,4681.1
X$97709 \$18 \$12945 \$10649 VSS INVR06
* cell instance $97710 m0 *1 3181,4681.1
X$97710 \$18 \$11913 \$13139 VSS INVR06
* cell instance $97711 m0 *1 3210.4,4681.1
X$97711 \$12482 \$13139 \$11226 \$18 VSS NND201
* cell instance $97712 m0 *1 3227.2,4681.1
X$97712 \$18 \$12483 \$13126 VSS INVR06
* cell instance $97714 r180 *1 3282.45,4681.1
X$97714 \$12484 \$12948 \$18 \$13142 VSS OR2101
* cell instance $97719 m0 *1 3344.52,4681.1
X$97719 \$18 \$11924 \$13142 VSS INVR03
* cell instance $97721 m0 *1 3366.91,4681.1
X$97721 \$11228 \$12952 \$18 \$11928 VSS OR2101
* cell instance $97724 r180 *1 3420.33,4681.1
X$97724 \$18 \$12953 \$12954 VSS INVR06
* cell instance $97727 r180 *1 3445.66,4681.1
X$97727 \$18 \$12490 \$12954 VSS INVR03
* cell instance $97804 m0 *1 4041.1,4681.1
X$97804 \$18 \$12956 \$6658 VSS INVR06
* cell instance $97897 r180 *1 4820.51,4681.1
X$97897 \$18 \$12493 \$13148 VSS INVR03
* cell instance $97899 m0 *1 4821.22,4681.1
X$97899 \$12349 \$18 \$12959 VSS INVR05
* cell instance $97900 m0 *1 4846.42,4681.1
X$97900 \$18 \$12344 \$12959 VSS INVR02
* cell instance $97903 m0 *1 4869.31,4681.1
X$97903 \$12503 \$18 \$12502 \$12500 VSS NOR201
* cell instance $97906 r180 *1 4933.05,4681.1
X$97906 \$18 \$12349 \$12963 VSS INVR02
* cell instance $97917 m0 *1 4999.06,4681.1
X$97917 \$18 \$12499 \$13255 VSS INVR02
* cell instance $97918 m0 *1 5015.86,4681.1
X$97918 \$18 \$13255 \$12497 VSS INVR02
* cell instance $97920 m0 *1 5087.26,4681.1
X$97920 \$11956 \$18 \$11955 \$11957 \$10463 VSS NND301
* cell instance $97921 m0 *1 5125.06,4681.1
X$97921 \$18 \$12506 \$13150 VSS INVR03
* cell instance $97926 m0 *1 5167.5,4681.1
X$97926 \$12971 \$18 \$12508 \$12190 VSS NOR201
* cell instance $97932 m0 *1 5232.54,4681.1
X$97932 \$18 \$12971 \$12973 VSS INVR02
* cell instance $97937 m0 *1 5271.01,4681.1
X$97937 \$18 \$12973 \$13152 VSS INVR03
* cell instance $97940 m0 *1 5291.11,4681.1
X$97940 \$18 \$12974 \$12975 VSS INVR02
* cell instance $97942 m0 *1 5307.91,4681.1
X$97942 \$18 \$12976 \$11269 VSS INVR03
* cell instance $97943 m0 *1 5324.71,4681.1
X$97943 \$18 \$12977 \$12976 VSS INVR02
* cell instance $97948 m0 *1 5361.32,4681.1
X$97948 \$18 \$13291 \$12513 VSS INVR02
* cell instance $97957 m0 *1 5533.52,4681.1
X$97957 \$18 \$13156 \$13240 VSS INVR03
* cell instance $97960 m0 *1 5556.61,4681.1
X$97960 \$18 \$7686 \$13240 VSS INVR06
* cell instance $98007 m0 *1 5944.62,4681.1
X$98007 \$18 \$12518 \$13158 VSS INVR03
* cell instance $98008 m0 *1 5962.74,4681.1
X$98008 \$18 \$10733 \$13237 VSS INVR02
* cell instance $98010 m0 *1 5979.54,4681.1
X$98010 \$18 \$13237 \$13159 VSS INVR03
* cell instance $98012 m0 *1 6005.19,4681.1
X$98012 \$8743 \$12527 \$13158 \$I331444 \$13162 \$18 VSS DFCL11
* cell instance $98015 r180 *1 6134.43,4681.1
X$98015 \$18 \$13159 \$12527 VSS INVR03
* cell instance $98017 m0 *1 6136,4681.1
X$98017 \$8743 \$12774 \$12368 \$I331407 \$12982 \$18 VSS DFCL11
* cell instance $98025 m0 *1 6268.66,4681.1
X$98025 \$18 \$12982 \$12984 VSS INVR02
* cell instance $98026 m0 *1 6285.46,4681.1
X$98026 \$18 \$12530 \$10118 VSS INVR03
* cell instance $98027 m0 *1 6304.21,4681.1
X$98027 \$18 \$12984 \$12373 VSS INVR03
* cell instance $98036 r180 *1 6472.93,4681.1
X$98036 \$8743 \$12776 \$12775 \$I331373 \$12533 \$18 VSS DFCL11
* cell instance $98038 m0 *1 6474.29,4681.1
X$98038 \$18 \$12986 \$13001 VSS INVR03
* cell instance $98043 r180 *1 6522.6,4681.1
X$98043 \$18 \$12794 \$13171 VSS INVR03
* cell instance $98044 m0 *1 6522.6,4681.1
X$98044 \$18 \$12537 \$12776 VSS INVR04
* cell instance $98045 m0 *1 6545.14,4681.1
X$98045 \$18 \$11980 \$11290 VSS INVR02
* cell instance $98048 r180 *1 6605.08,4681.1
X$98048 \$12794 \$18 \$12992 \$13175 VSS NOR201
* cell instance $98055 m0 *1 6636.28,4681.1
X$98055 \$8743 \$12777 \$13178 \$I331409 \$13180 \$18 VSS DFCL11
* cell instance $98059 r180 *1 6771.59,4681.1
X$98059 \$18 \$12993 \$13178 VSS INVR03
* cell instance $98065 r180 *1 6827.94,4681.1
X$98065 \$12993 \$18 \$12541 \$13182 VSS NOR201
* cell instance $98067 r180 *1 6857.95,4681.1
X$98067 \$18 \$12994 \$12995 \$12996 VSS AND201
* cell instance $98069 m0 *1 6867,4681.1
X$98069 \$18 \$12997 \$12996 VSS INVR02
* cell instance $98073 r180 *1 6923.93,4681.1
X$98073 \$12992 \$18 \$13000 \$12543 \$12996 VSS AND301
* cell instance $98078 m0 *1 6951,4681.1
X$98078 \$18 \$13001 \$13184 VSS INVR03
* cell instance $98085 r180 *1 7026.61,4681.1
X$98085 \$18 \$12545 \$13000 VSS INVR03
* cell instance $98087 m0 *1 7026.61,4681.1
X$98087 \$13003 \$18 \$12376 VSS INVR05
* cell instance $98090 r180 *1 7086.01,4681.1
X$98090 \$18 \$12546 \$13004 VSS INVR02
* cell instance $98138 m0 *1 7454.01,4681.1
X$98138 \$18 \$13005 \$12547 VSS INVR06
* cell instance $98139 m0 *1 7483.41,4681.1
X$98139 \$12547 \$18 \$13187 VSS INVR05
* cell instance $98163 m0 *1 7688.3,4681.1
X$98163 \$12780 \$18 \$12378 VSS INVR05
* cell instance $98280 m0 *1 8625.36,4681.1
X$98280 \$18 \$12379 \$13189 VSS INVR03
* cell instance $98307 m0 *1 8835.98,4681.1
X$98307 \$18 \$12780 \$13012 VSS INVR02
* cell instance $98311 m0 *1 8868.22,4681.1
X$98311 \$18 \$13005 \$13013 VSS INVR02
* cell instance $98314 m0 *1 31.11,4326.3
X$98314 \$18 \$10555 \$9993 VSS INVR03
* cell instance $98316 m0 *1 53.3,4326.3
X$98316 \$18 \$10400 \$9997 VSS INVR03
* cell instance $98318 m0 *1 70.1,4326.3
X$98318 \$18 \$9649 \$9426 VSS INVR03
* cell instance $98324 m0 *1 123.12,4326.3
X$98324 \$18 \$9877 \$10561 VSS INVR03
* cell instance $98334 m0 *1 307.71,4326.3
X$98334 \$18 \$10786 \$10732 VSS INVR02
* cell instance $98335 m0 *1 324.51,4326.3
X$98335 \$18 \$10732 \$10564 VSS INVR03
* cell instance $98336 m0 *1 341.31,4326.3
X$98336 \$10787 \$18 \$7867 VSS INVR01
* cell instance $98339 m0 *1 360.67,4326.3
X$98339 \$18 \$6777 \$10735 VSS INVR02
* cell instance $98340 m0 *1 377.48,4326.3
X$98340 \$18 \$10735 \$10565 VSS INVR03
* cell instance $98347 m0 *1 429.66,4326.3
X$98347 \$18 \$10789 \$10561 VSS INVR06
* cell instance $98348 m0 *1 459.06,4326.3
X$98348 \$10189 \$10569 \$10568 \$18 \$9431 VSS OR3101
* cell instance $98349 m0 *1 490.01,4326.3
X$98349 \$10792 \$10569 \$10570 \$18 VSS NND201
* cell instance $98351 r180 *1 519.42,4326.3
X$98351 \$10001 \$18 \$10007 VSS INVR01
* cell instance $98353 r180 *1 545.11,4326.3
X$98353 \$10002 \$10790 \$18 \$10570 VSS OR2101
* cell instance $98354 m0 *1 545.11,4326.3
X$98354 \$18 \$9442 \$9660 VSS INVR03
* cell instance $98357 m0 *1 571.2,4326.3
X$98357 \$18 \$10573 \$10572 VSS INVR06
* cell instance $98360 r180 *1 641.83,4326.3
X$98360 \$8967 \$18 \$10007 \$9660 \$10416 VSS ADNR01
* cell instance $98361 r180 *1 658.63,4326.3
X$98361 \$18 \$8967 \$10575 VSS INVR02
* cell instance $98362 m0 *1 658.63,4326.3
X$98362 \$18 \$10006 \$10570 VSS INVR02
* cell instance $98364 m0 *1 684.43,4326.3
X$98364 \$18 \$10803 \$10802 \$10801 VSS AND201
* cell instance $98367 m0 *1 714.43,4326.3
X$98367 \$10009 \$10581 \$18 \$10007 VSS OR2101
* cell instance $98370 m0 *1 747.6,4326.3
X$98370 \$10805 \$18 \$10804 VSS INVR05
* cell instance $98372 r180 *1 793.81,4326.3
X$98372 \$18 \$10582 \$10806 VSS INVR03
* cell instance $98373 m0 *1 793.81,4326.3
X$98373 \$18 \$10201 \$10416 \$10581 VSS AND201
* cell instance $98374 r180 *1 836.75,4326.3
X$98374 \$18 \$10585 \$10012 VSS INVR03
* cell instance $98378 m0 *1 962.41,4326.3
X$98378 \$18 \$11573 \$10588 VSS INVR04
* cell instance $98379 m0 *1 1000.21,4326.3
X$98379 \$18 \$6523 \$7339 VSS INVR06
* cell instance $98385 m0 *1 1182.15,4326.3
X$98385 \$18 \$10755 \$10208 VSS INVR02
* cell instance $98388 m0 *1 1205.47,4326.3
X$98388 \$18 \$10813 \$10591 VSS INVR03
* cell instance $98392 m0 *1 1243.82,4326.3
X$98392 \$18 \$10592 \$7508 VSS INVR03
* cell instance $98394 m0 *1 1260.62,4326.3
X$98394 \$18 \$10594 \$10595 VSS INVR03
* cell instance $98396 m0 *1 1279.52,4326.3
X$98396 \$18 \$10595 \$10020 VSS INVR02
* cell instance $98399 m0 *1 1306.97,4326.3
X$98399 \$18 \$10591 \$9482 VSS INVR02
* cell instance $98400 m0 *1 1323.77,4326.3
X$98400 \$18 \$7518 \$10815 VSS INVR02
* cell instance $98408 m0 *1 1393.24,4326.3
X$98408 \$18 \$10036 \$10928 VSS INVR03
* cell instance $98410 m0 *1 1412.14,4326.3
X$98410 \$18 \$10597 \$10928 VSS INVR06
* cell instance $98411 m0 *1 1441.55,4326.3
X$98411 \$18 \$8983 \$10037 VSS INVR02
* cell instance $98416 m0 *1 1480.71,4326.3
X$98416 \$18 \$10041 \$10599 VSS INVR03
* cell instance $98417 m0 *1 1497.51,4326.3
X$98417 \$18 \$10599 \$10588 VSS INVR03
* cell instance $98418 m0 *1 1514.31,4326.3
X$98418 \$18 \$9213 \$10789 VSS INVR06
* cell instance $98424 m0 *1 1579.76,4326.3
X$98424 \$18 \$9315 \$10214 VSS INVR03
* cell instance $98431 r180 *1 1663.56,4326.3
X$98431 \$10042 \$10767 \$18 \$9316 VSS OR2101
* cell instance $98433 m0 *1 1663.56,4326.3
X$98433 \$18 \$10767 \$10215 VSS INVR03
* cell instance $98436 r180 *1 1703.96,4326.3
X$98436 \$18 \$10429 \$10042 VSS INVR02
* cell instance $98437 m0 *1 1703.97,4326.3
X$98437 \$18 \$10603 \$10429 VSS INVR02
* cell instance $98448 r180 *1 1850.85,4326.3
X$98448 \$18 \$8995 \$10820 VSS INVR02
* cell instance $98449 m0 *1 1850.85,4326.3
X$98449 \$18 \$8756 \$10605 VSS INVR02
* cell instance $98453 m0 *1 1875.41,4326.3
X$98453 \$18 \$9129 \$10180 VSS INVR06
* cell instance $98454 m0 *1 1904.81,4326.3
X$98454 \$18 \$9001 \$10606 VSS INVR03
* cell instance $98460 m0 *1 1957.23,4326.3
X$98460 \$18 \$10608 \$10222 \$10607 VSS AND201
* cell instance $98462 m0 *1 1982.43,4326.3
X$98462 \$18 \$9000 \$10218 VSS INVR02
* cell instance $98463 m0 *1 1999.23,4326.3
X$98463 \$18 \$10822 \$9511 \$10821 VSS AND201
* cell instance $98464 m0 *1 2024.43,4326.3
X$98464 \$18 \$10218 \$10219 VSS INVR02
* cell instance $98465 r180 *1 2066.43,4326.3
X$98465 \$18 \$10609 \$10637 \$10825 VSS AND201
* cell instance $98470 m0 *1 2092.22,4326.3
X$98470 \$18 \$10611 \$10573 VSS INVR06
* cell instance $98473 m0 *1 2132.37,4326.3
X$98473 \$18 \$10608 \$10612 VSS INVR02
* cell instance $98474 m0 *1 2149.17,4326.3
X$98474 \$9001 \$18 \$10613 VSS INVR05
* cell instance $98477 m0 *1 2183.71,4326.3
X$98477 \$18 \$10614 \$9330 VSS INVR06
* cell instance $98478 m0 *1 2213.96,4326.3
X$98478 \$18 \$9512 \$10829 \$10436 VSS AND201
* cell instance $98481 r180 *1 2262.09,4326.3
X$98481 \$18 \$10050 \$10830 VSS INVR02
* cell instance $98485 r180 *1 2298.56,4326.3
X$98485 \$18 \$10435 \$10049 VSS INVR02
* cell instance $98488 m0 *1 2302.2,4326.3
X$98488 \$18 \$11022 \$6654 VSS INVR03
* cell instance $98490 m0 *1 2319.01,4326.3
X$98490 \$18 \$10617 \$10618 VSS INVR02
* cell instance $98495 m0 *1 2365.32,4326.3
X$98495 \$18 \$7288 \$11024 VSS INVR02
* cell instance $98497 m0 *1 2382.12,4326.3
X$98497 \$10231 \$10620 \$10607 \$18 VSS NND201
* cell instance $98498 r180 *1 2453.52,4326.3
X$98498 \$10061 \$9515 \$8212 \$10435 \$10842 \$10841 \$10237 \$18 VSS ADOR16
* cell instance $98499 r180 *1 2470.32,4326.3
X$98499 \$8670 \$8473 \$10842 \$18 VSS NND201
* cell instance $98502 m0 *1 2480.93,4326.3
X$98502 \$10849 \$18 \$10235 VSS INVR05
* cell instance $98504 r180 *1 2526.14,4326.3
X$98504 \$18 \$10622 \$10230 VSS INVR02
* cell instance $98507 r180 *1 2556.14,4326.3
X$98507 \$18 \$10622 \$10373 \$10620 VSS AND201
* cell instance $98508 r180 *1 2581.34,4326.3
X$98508 \$18 \$10624 \$10441 \$10853 VSS AND201
* cell instance $98509 r180 *1 2603.64,4326.3
X$98509 \$10240 \$10441 \$18 \$10237 VSS OR2101
* cell instance $98511 r180 *1 2621.05,4326.3
X$98511 \$18 \$9012 \$11030 VSS INVR02
* cell instance $98512 r180 *1 2633.65,4326.3
X$98512 \$10240 \$18 \$10072 VSS INVR01
* cell instance $98516 r180 *1 2669.67,4326.3
X$98516 \$9853 \$10625 \$18 \$10628 VSS OR2101
* cell instance $98518 m0 *1 2669.67,4326.3
X$98518 \$10628 \$18 \$9527 VSS INVR01
* cell instance $98519 r180 *1 2699.07,4326.3
X$98519 \$10373 \$10059 \$8206 \$18 VSS NND201
* cell instance $98521 m0 *1 2701.84,4326.3
X$98521 \$18 \$9853 \$10629 VSS INVR03
* cell instance $98522 r180 *1 2748.04,4326.3
X$98522 \$18 \$10630 \$7624 VSS INVR06
* cell instance $98525 r180 *1 2791.55,4326.3
X$98525 \$9017 \$18 \$10064 \$9220 VSS NOR201
* cell instance $98526 r180 *1 2808.35,4326.3
X$98526 \$9685 \$10634 \$10633 \$18 VSS NND201
* cell instance $98529 m0 *1 2821.55,4326.3
X$98529 \$18 \$8691 \$10065 VSS INVR03
* cell instance $98533 r180 *1 2868.35,4326.3
X$98533 \$18 \$10636 \$10635 VSS INVR03
* cell instance $98535 r180 *1 2893.55,4326.3
X$98535 \$10637 \$18 \$10638 VSS INVR05
* cell instance $98536 r180 *1 2915.97,4326.3
X$98536 \$10640 \$10529 \$18 \$9529 VSS OR2101
* cell instance $98538 m0 *1 2915.97,4326.3
X$98538 \$18 \$8691 \$10641 VSS INVR03
* cell instance $98539 r180 *1 2949.57,4326.3
X$98539 \$18 \$10529 \$10638 VSS INVR02
* cell instance $98541 m0 *1 2954.77,4326.3
X$98541 \$10064 \$10449 \$10640 \$18 \$9930 VSS OR3101
* cell instance $98548 m0 *1 3014.18,4326.3
X$98548 \$18 \$10074 \$10641 VSS INVR06
* cell instance $98551 m0 *1 3055.33,4326.3
X$98551 \$18 \$10644 \$10452 \$10449 VSS AND201
* cell instance $98555 r180 *1 3114.28,4326.3
X$98555 \$9220 \$10452 \$18 \$10075 VSS OR2101
* cell instance $98559 m0 *1 3128.53,4326.3
X$98559 \$18 \$10648 \$10649 VSS INVR03
* cell instance $98563 m0 *1 3159.67,4326.3
X$98563 \$10651 \$18 \$10650 VSS INVR05
* cell instance $98564 m0 *1 3184.87,4326.3
X$98564 \$18 \$10653 \$10652 VSS INVR06
* cell instance $98565 r180 *1 3231.07,4326.3
X$98565 \$10654 \$10655 \$8617 \$18 VSS NND201
* cell instance $98567 m0 *1 3240.42,4326.3
X$98567 \$10092 \$18 \$10078 VSS INVR05
* cell instance $98572 m0 *1 3290.58,4326.3
X$98572 \$18 \$10083 \$10655 VSS INVR03
* cell instance $98582 m0 *1 3380.59,4326.3
X$98582 \$18 \$10611 \$10989 VSS INVR03
* cell instance $98585 m0 *1 3400.98,4326.3
X$98585 \$10659 \$18 \$10989 VSS INVR05
* cell instance $98600 m0 *1 3520.8,4326.3
X$98600 \$18 \$10455 \$10660 VSS INVR03
* cell instance $98601 m0 *1 3537.6,4326.3
X$98601 \$10455 \$18 \$10661 VSS INVR05
* cell instance $98602 m0 *1 3562.8,4326.3
X$98602 \$18 \$9330 \$10660 VSS INVR06
* cell instance $98646 m0 *1 3927,4326.3
X$98646 \$18 \$10663 \$2637 VSS INVR06
* cell instance $98665 m0 *1 4091.81,4326.3
X$98665 \$10665 \$18 \$10659 VSS INVR05
* cell instance $98672 m0 *1 4152,4326.3
X$98672 \$18 \$10108 \$10666 VSS INVR06
* cell instance $98673 m0 *1 4181.4,4326.3
X$98673 \$18 \$10667 \$9544 VSS INVR06
* cell instance $98680 r180 *1 4267.93,4326.3
X$98680 \$18 \$10457 \$10668 \$10096 VSS AND201
* cell instance $98681 m0 *1 4267.93,4326.3
X$98681 \$18 \$10457 \$10669 VSS INVR02
* cell instance $98683 m0 *1 4287.61,4326.3
X$98683 \$18 \$10089 \$10671 VSS INVR03
* cell instance $98696 m0 *1 4400.46,4326.3
X$98696 \$18 \$10098 \$10741 VSS INVR02
* cell instance $98697 m0 *1 4417.26,4326.3
X$98697 \$18 \$10741 \$10095 VSS INVR02
* cell instance $98705 m0 *1 4491.91,4326.3
X$98705 \$10673 \$18 \$10672 VSS INVR01
* cell instance $98707 m0 *1 4504.51,4326.3
X$98707 \$18 \$10674 \$10672 VSS INVR03
* cell instance $98733 m0 *1 4721.71,4326.3
X$98733 \$18 \$10672 \$10677 VSS INVR03
* cell instance $98751 r180 *1 4888.5,4326.3
X$98751 \$18 \$10460 \$10678 VSS INVR03
* cell instance $98755 r180 *1 4931.94,4326.3
X$98755 \$10460 \$18 \$10461 \$10679 VSS NOR201
* cell instance $98758 m0 *1 4935.57,4326.3
X$98758 \$18 \$10661 \$9237 VSS INVR06
* cell instance $98759 r180 *1 4981.83,4326.3
X$98759 \$10461 \$10682 \$10867 \$18 VSS NND201
* cell instance $98767 m0 *1 5034.02,4326.3
X$98767 \$10682 \$18 \$10683 \$10671 \$10463 VSS NND301
* cell instance $98770 m0 *1 5079.1,4326.3
X$98770 \$10687 \$18 \$10111 VSS INVR01
* cell instance $98772 r180 *1 5137.9,4326.3
X$98772 \$9133 \$10464 \$10688 \$10687 \$10112 \$18 VSS AOI401
* cell instance $98773 m0 *1 5137.9,4326.3
X$98773 \$10464 \$18 \$9707 VSS INVR01
* cell instance $98774 m0 *1 5150.5,4326.3
X$98774 \$10691 \$18 \$10093 VSS INVR05
* cell instance $98776 m0 *1 5180.61,4326.3
X$98776 \$10694 \$18 \$10692 \$10693 VSS NOR201
* cell instance $98777 m0 *1 5214.21,4326.3
X$98777 \$18 \$10665 \$10696 VSS INVR03
* cell instance $98791 m0 *1 5324.5,4326.3
X$98791 \$18 \$6662 \$10697 VSS INVR06
* cell instance $98792 m0 *1 5353.91,4326.3
X$98792 \$18 \$10697 \$10698 VSS INVR06
* cell instance $98799 m0 *1 5427.09,4326.3
X$98799 \$18 \$10688 \$7470 VSS INVR02
* cell instance $98801 m0 *1 5444.82,4326.3
X$98801 \$9037 \$18 \$10701 VSS INVR05
* cell instance $98804 m0 *1 5482.32,4326.3
X$98804 \$18 \$10105 \$10943 VSS INVR03
* cell instance $98805 m0 *1 5499.12,4326.3
X$98805 \$18 \$9577 \$10943 VSS INVR06
* cell instance $98806 m0 *1 5530.27,4326.3
X$98806 \$18 \$10114 \$10268 VSS INVR03
* cell instance $98815 m0 *1 5592.13,4326.3
X$98815 \$18 \$10706 \$9580 VSS INVR06
* cell instance $98842 m0 *1 5812.77,4326.3
X$98842 \$18 \$7614 \$10132 VSS INVR06
* cell instance $98849 m0 *1 5890.44,4326.3
X$98849 \$18 \$10114 \$10120 VSS INVR03
* cell instance $98850 r180 *1 5924.05,4326.3
X$98850 \$18 \$10119 \$9809 VSS INVR03
* cell instance $98855 m0 *1 5950.45,4326.3
X$98855 \$18 \$10733 \$10122 VSS INVR02
* cell instance $98858 m0 *1 5974.22,4326.3
X$98858 \$10133 \$18 \$10121 VSS INVR05
* cell instance $98859 m0 *1 5999.42,4326.3
X$98859 \$18 \$10696 \$9578 VSS INVR02
* cell instance $98860 m0 *1 6016.22,4326.3
X$98860 \$18 \$9713 \$10123 VSS INVR03
* cell instance $98863 m0 *1 6046.56,4326.3
X$98863 \$18 \$10712 \$10713 VSS INVR03
* cell instance $98867 m0 *1 6068.96,4326.3
X$98867 \$18 \$9575 \$10341 VSS INVR06
* cell instance $98868 m0 *1 6098.36,4326.3
X$98868 \$18 \$10341 \$10713 VSS INVR06
* cell instance $98869 m0 *1 6128.36,4326.3
X$98869 \$18 \$10691 \$11284 VSS INVR02
* cell instance $98872 m0 *1 6304.15,4326.3
X$98872 \$18 \$10882 \$10912 VSS INVR03
* cell instance $98875 m0 *1 6323.05,4326.3
X$98875 \$18 \$9237 \$10912 VSS INVR06
* cell instance $98876 m0 *1 6352.46,4326.3
X$98876 \$18 \$10881 \$10882 VSS INVR03
* cell instance $98881 m0 *1 6398.08,4326.3
X$98881 \$10135 \$18 \$8896 VSS INVR01
* cell instance $98885 m0 *1 6432.05,4326.3
X$98885 \$18 \$10719 \$9820 VSS INVR03
* cell instance $98906 m0 *1 6596.81,4326.3
X$98906 \$10136 \$18 \$10141 VSS INVR05
* cell instance $98917 m0 *1 6690.6,4326.3
X$98917 \$18 \$10280 \$10136 VSS INVR06
* cell instance $98994 m0 *1 7329,4326.3
X$98994 \$18 \$10725 \$10724 VSS INVR02
* cell instance $99191 m0 *1 23.16,3971.5
X$99191 \$18 \$8519 \$8520 VSS INVR03
* cell instance $99195 m0 *1 64.2,3971.5
X$99195 \$18 \$8521 \$7246 VSS INVR03
* cell instance $99197 m0 *1 183.9,3971.5
X$99197 \$18 \$8116 \$7039 VSS INVR03
* cell instance $99200 m0 *1 213.91,3971.5
X$99200 \$18 \$7391 \$8528 VSS INVR03
* cell instance $99205 m0 *1 250.57,3971.5
X$99205 \$7686 \$7859 \$7489 \$8405 \$8526 \$18 VSS AND401
* cell instance $99209 r180 *1 318.24,3971.5
X$99209 \$18 \$7247 \$8122 VSS INVR02
* cell instance $99211 m0 *1 318.37,3971.5
X$99211 \$8121 \$18 \$8528 VSS INVR01
* cell instance $99212 m0 *1 330.97,3971.5
X$99212 \$18 \$8529 \$8630 VSS INVR02
* cell instance $99213 m0 *1 347.77,3971.5
X$99213 \$18 \$8630 \$8530 VSS INVR03
* cell instance $99215 r180 *1 383.64,3971.5
X$99215 \$18 \$8532 \$8531 VSS INVR02
* cell instance $99219 m0 *1 402.89,3971.5
X$99219 \$18 \$8408 \$6326 VSS INVR03
* cell instance $99223 m0 *1 431.36,3971.5
X$99223 \$8534 \$8536 \$18 \$5730 VSS OR2101
* cell instance $99225 m0 *1 452.36,3971.5
X$99225 \$18 \$8538 \$8533 VSS INVR04
* cell instance $99229 m0 *1 491.67,3971.5
X$99229 \$18 \$8540 \$8409 \$7332 VSS AND201
* cell instance $99232 r180 *1 539.95,3971.5
X$99232 \$8410 \$8135 \$8540 \$18 VSS NND201
* cell instance $99233 m0 *1 539.95,3971.5
X$99233 \$18 \$8410 \$8356 VSS INVR02
* cell instance $99236 m0 *1 572.77,3971.5
X$99236 \$18 \$7780 \$8409 VSS INVR02
* cell instance $99239 m0 *1 601.31,3971.5
X$99239 \$8137 \$8409 \$8414 \$18 VSS XNR201
* cell instance $99244 m0 *1 653.22,3971.5
X$99244 \$18 \$8543 \$6332 \$8414 VSS AND201
* cell instance $99245 m0 *1 678.42,3971.5
X$99245 \$18 \$8544 \$8011 VSS INVR03
* cell instance $99249 m0 *1 814.9,3971.5
X$99249 \$18 \$8745 \$8547 VSS INVR03
* cell instance $99252 m0 *1 842.51,3971.5
X$99252 \$8320 \$18 \$8144 VSS INVR01
* cell instance $99253 r180 *1 889.13,3971.5
X$99253 \$8418 \$18 \$8145 \$8147 VSS NOR201
* cell instance $99254 r180 *1 905.93,3971.5
X$99254 \$18 \$8548 \$8419 VSS INVR02
* cell instance $99256 m0 *1 914.3,3971.5
X$99256 \$18 \$7500 \$8550 VSS INVR02
* cell instance $99257 r180 *1 947.9,3971.5
X$99257 \$18 \$8419 \$8150 VSS INVR02
* cell instance $99259 m0 *1 950.94,3971.5
X$99259 \$18 \$8421 \$6677 VSS INVR03
* cell instance $99261 m0 *1 967.74,3971.5
X$99261 \$18 \$8380 \$8421 VSS INVR02
* cell instance $99265 r180 *1 1033.84,3971.5
X$99265 \$8380 \$18 \$8548 \$8147 VSS NOR201
* cell instance $99268 m0 *1 1038.5,3971.5
X$99268 \$8556 \$18 \$8548 \$8147 VSS NOR201
* cell instance $99269 m0 *1 1072.11,3971.5
X$99269 \$18 \$8322 \$7701 VSS INVR02
* cell instance $99272 m0 *1 1102.11,3971.5
X$99272 \$18 \$8557 \$8558 VSS INVR03
* cell instance $99282 m0 *1 1170.51,3971.5
X$99282 \$18 \$4342 \$8558 VSS INVR06
* cell instance $99283 m0 *1 1199.91,3971.5
X$99283 \$18 \$8560 \$8257 VSS INVR02
* cell instance $99285 m0 *1 1219.46,3971.5
X$99285 \$18 \$8257 \$8326 VSS INVR03
* cell instance $99287 m0 *1 1244.62,3971.5
X$99287 \$5753 \$8161 \$18 \$6270 \$6534 VSS NOR301
* cell instance $99288 r180 *1 1303.42,3971.5
X$99288 \$8565 \$8751 \$18 \$8564 VSS OR2101
* cell instance $99289 m0 *1 1303.42,3971.5
X$99289 \$18 \$8564 \$8161 \$6880 VSS AND201
* cell instance $99291 r180 *1 1358.75,3971.5
X$99291 \$8326 \$7795 \$18 \$8564 VSS OR2101
* cell instance $99296 m0 *1 1373.18,3971.5
X$99296 \$18 \$7607 \$8570 \$8326 VSS AND201
* cell instance $99297 m0 *1 1399.37,3971.5
X$99297 \$8571 \$18 \$8024 \$8570 \$8326 VSS AND301
* cell instance $99300 m0 *1 1443.71,3971.5
X$99300 \$18 \$8171 \$8573 VSS INVR03
* cell instance $99301 m0 *1 1460.51,3971.5
X$99301 \$18 \$8573 \$8322 VSS INVR02
* cell instance $99302 m0 *1 1477.31,3971.5
X$99302 \$18 \$8154 \$8434 VSS INVR02
* cell instance $99303 m0 *1 1494.11,3971.5
X$99303 \$18 \$8434 \$8574 VSS INVR02
* cell instance $99304 m0 *1 1510.91,3971.5
X$99304 \$18 \$7879 \$8575 VSS INVR06
* cell instance $99305 m0 *1 1540.31,3971.5
X$99305 \$8169 \$8327 \$18 \$8571 VSS OR2101
* cell instance $99307 r180 *1 1577.92,3971.5
X$99307 \$8174 \$18 \$7529 VSS INVR01
* cell instance $99312 m0 *1 1675.31,3971.5
X$99312 \$8438 \$18 \$3416 VSS INVR05
* cell instance $99316 m0 *1 1812.76,3971.5
X$99316 \$18 \$5891 \$8583 VSS INVR06
* cell instance $99338 m0 *1 2001.13,3971.5
X$99338 \$8585 \$18 \$8661 VSS INVR05
* cell instance $99342 r180 *1 2057.41,3971.5
X$99342 \$18 \$8587 \$8586 VSS INVR02
* cell instance $99350 m0 *1 2107.93,3971.5
X$99350 \$7193 \$18 \$7562 VSS INVR05
* cell instance $99351 m0 *1 2133.13,3971.5
X$99351 \$18 \$8183 \$8189 VSS INVR02
* cell instance $99355 m0 *1 2165.08,3971.5
X$99355 \$18 \$8592 \$7562 \$8184 VSS AND201
* cell instance $99359 m0 *1 2204.17,3971.5
X$99359 \$8192 \$18 \$6916 \$8182 \$7188 VSS AND301
* cell instance $99362 m0 *1 2239.18,3971.5
X$99362 \$18 \$9116 \$8593 VSS INVR06
* cell instance $99363 m0 *1 2268.58,3971.5
X$99363 \$18 \$8668 \$8184 VSS INVR06
* cell instance $99366 r180 *1 2328.65,3971.5
X$99366 \$18 \$8669 \$8670 \$8672 VSS AND201
* cell instance $99368 r180 *1 2354,3971.5
X$99368 \$18 \$8337 \$8336 VSS INVR02
* cell instance $99369 m0 *1 2354,3971.5
X$99369 \$8202 \$8336 \$8596 \$18 VSS PDDR02
* cell instance $99370 r180 *1 2438.01,3971.5
X$99370 \$18 \$9117 \$8337 VSS INVR02
* cell instance $99375 r180 *1 2491.07,3971.5
X$99375 \$18 \$8597 \$8676 VSS INVR06
* cell instance $99377 r180 *1 2516.27,3971.5
X$99377 \$18 \$8271 \$7933 \$8342 VSS AND201
* cell instance $99379 r180 *1 2546.27,3971.5
X$99379 \$7573 \$8342 \$18 \$7930 VSS OR2101
* cell instance $99382 r180 *1 2571.6,3971.5
X$99382 \$18 \$8456 \$8274 VSS INVR02
* cell instance $99385 r180 *1 2603.67,3971.5
X$99385 \$18 \$8599 \$8215 \$7569 VSS AND201
* cell instance $99389 r180 *1 2640.08,3971.5
X$99389 \$7839 \$8456 \$18 \$8600 VSS OR2101
* cell instance $99391 m0 *1 2640.96,3971.5
X$99391 \$18 \$8774 \$8602 VSS INVR06
* cell instance $99394 r180 *1 2705.28,3971.5
X$99394 \$18 \$8600 \$8212 \$9014 VSS AND201
* cell instance $99399 m0 *1 2767.8,3971.5
X$99399 \$18 \$8602 \$8605 VSS INVR06
* cell instance $99400 m0 *1 2797.2,3971.5
X$99400 \$18 \$8457 \$8602 VSS INVR06
* cell instance $99406 r180 *1 2878.54,3971.5
X$99406 \$8608 \$8346 \$8691 \$18 VSS NND201
* cell instance $99410 m0 *1 2889.56,3971.5
X$99410 \$18 \$8212 \$8611 VSS INVR02
* cell instance $99416 m0 *1 2935.16,3971.5
X$99416 \$8346 \$8612 \$8613 \$18 VSS NND201
* cell instance $99417 m0 *1 2953.79,3971.5
X$99417 \$18 \$8461 \$8614 \$8457 VSS AND201
* cell instance $99422 m0 *1 2997.34,3971.5
X$99422 \$18 \$8461 \$8214 VSS INVR02
* cell instance $99431 r180 *1 3090.77,3971.5
X$99431 \$8457 \$8463 \$18 \$8216 VSS OR2101
* cell instance $99433 m0 *1 3090.77,3971.5
X$99433 \$18 \$8463 \$8629 VSS INVR03
* cell instance $99434 m0 *1 3108.39,3971.5
X$99434 \$8617 \$18 \$8629 VSS INVR05
* cell instance $99437 m0 *1 3144.29,3971.5
X$99437 \$8218 \$8618 \$8779 \$18 VSS NND201
* cell instance $99586 m0 *1 4338.18,3971.5
X$99586 \$18 \$8619 \$6661 VSS INVR06
* cell instance $99790 m0 *1 5987.58,3971.5
X$99790 \$18 \$8620 \$8621 VSS INVR03
* cell instance $99797 m0 *1 6049.2,3971.5
X$99797 \$18 \$8464 \$8622 VSS INVR06
* cell instance $100135 m0 *1 8774.84,3971.5
X$100135 \$18 \$7218 \$8623 VSS INVR02
* cell instance $100142 m0 *1 8840.19,3971.5
X$100142 \$18 \$7846 \$8466 VSS INVR02
* cell instance $100145 m0 *1 8867.42,3971.5
X$100145 \$18 \$8623 \$8625 VSS INVR02
* cell instance $100147 r0 *1 24.9,4366.3
X$100147 \$18 \$11107 \$10779 VSS INVR03
* cell instance $100150 r0 *1 55.65,4366.3
X$100150 \$10572 \$18 \$10993 VSS INVR05
* cell instance $100158 m90 *1 137.03,4366.3
X$100158 \$18 \$11112 \$5110 VSS INVR02
* cell instance $100164 r0 *1 161.01,4366.3
X$100164 \$18 \$10779 \$10791 VSS INVR03
* cell instance $100167 r0 *1 183.75,4366.3
X$100167 \$18 \$11114 \$11115 VSS INVR03
* cell instance $100172 r0 *1 220.18,4366.3
X$100172 \$18 \$10562 \$10998 VSS INVR03
* cell instance $100176 r0 *1 247.78,4366.3
X$100176 \$9424 \$18 \$10998 VSS INVR05
* cell instance $100180 r0 *1 286.86,4366.3
X$100180 \$11125 \$18 \$11116 \$9424 VSS NOR201
* cell instance $100181 r0 *1 320.46,4366.3
X$100181 \$10999 \$18 \$7481 \$10787 VSS NOR201
* cell instance $100183 r0 *1 356.17,4366.3
X$100183 \$18 \$11119 \$11563 VSS INVR06
* cell instance $100184 r0 *1 387.06,4366.3
X$100184 \$9881 \$10999 \$8530 \$18 VSS NND201
* cell instance $100186 m90 *1 437.47,4366.3
X$100186 \$10786 \$18 \$11330 \$9429 VSS NOR201
* cell instance $100189 m90 *1 474.94,4366.3
X$100189 \$18 \$11330 \$10792 \$10790 VSS AND201
* cell instance $100191 r0 *1 476.11,4366.3
X$100191 \$18 \$11122 \$10791 VSS INVR06
* cell instance $100192 m90 *1 522.31,4366.3
X$100192 \$18 \$11683 \$11334 VSS INVR02
* cell instance $100193 r0 *1 522.31,4366.3
X$100193 \$18 \$10189 \$11124 VSS INVR02
* cell instance $100194 r0 *1 539.11,4366.3
X$100194 \$10802 \$11124 \$11125 \$18 VSS NND201
* cell instance $100195 r0 *1 555.92,4366.3
X$100195 \$18 \$9300 \$11565 VSS INVR02
* cell instance $100199 r0 *1 588,4366.3
X$100199 \$18 \$9422 \$10006 VSS INVR02
* cell instance $100203 m90 *1 628.99,4366.3
X$100203 \$18 \$10575 \$10189 VSS INVR02
* cell instance $100206 r0 *1 633.6,4366.3
X$100206 \$10190 \$10801 \$18 \$9299 VSS OR2101
* cell instance $100209 r0 *1 672.2,4366.3
X$100209 \$18 \$11130 \$10582 VSS INVR03
* cell instance $100211 r0 *1 689,4366.3
X$100211 \$18 \$11568 \$10416 VSS INVR03
* cell instance $100212 r0 *1 705.95,4366.3
X$100212 \$18 \$11340 \$10802 \$10801 VSS AND201
* cell instance $100215 r0 *1 743.81,4366.3
X$100215 \$10804 \$18 \$10806 VSS INVR05
* cell instance $100216 r0 *1 769.01,4366.3
X$100216 \$18 \$10614 \$11342 VSS INVR02
* cell instance $100217 r0 *1 785.81,4366.3
X$100217 \$18 \$10007 \$10804 VSS INVR06
* cell instance $100218 r0 *1 815.81,4366.3
X$100218 \$18 \$11340 \$11133 VSS INVR02
* cell instance $100221 r0 *1 846.37,4366.3
X$100221 \$18 \$11342 \$7498 VSS INVR03
* cell instance $100223 m90 *1 879.97,4366.3
X$100223 \$18 \$10565 \$10585 VSS INVR03
* cell instance $100224 r0 *1 879.97,4366.3
X$100224 \$18 \$10015 \$11133 \$11136 VSS AND201
* cell instance $100240 r0 *1 1034.12,4366.3
X$100240 \$18 \$10591 \$10586 VSS INVR03
* cell instance $100242 m90 *1 1084.52,4366.3
X$100242 \$11141 \$18 \$11143 \$11142 VSS NOR201
* cell instance $100243 r0 *1 1084.52,4366.3
X$100243 \$18 \$11144 \$10028 VSS INVR02
* cell instance $100244 m90 *1 1218.92,4366.3
X$100244 \$18 \$11150 \$11142 VSS INVR02
* cell instance $100248 r0 *1 1233.85,4366.3
X$100248 \$18 \$11148 \$11152 VSS INVR03
* cell instance $100251 m90 *1 1293.85,4366.3
X$100251 \$18 \$6610 \$11354 VSS INVR06
* cell instance $100254 r0 *1 1296.77,4366.3
X$100254 \$18 \$10033 \$11354 VSS INVR02
* cell instance $100261 r0 *1 1374.47,4366.3
X$100261 \$11155 \$11156 \$18 \$11356 \$11154 VSS NOR301
* cell instance $100262 r0 *1 1412.28,4366.3
X$100262 \$18 \$10813 \$10597 VSS INVR06
* cell instance $100267 r0 *1 1471.78,4366.3
X$100267 \$18 \$11158 \$10594 VSS INVR03
* cell instance $100269 m90 *1 1507.17,4366.3
X$100269 \$18 \$11159 \$11358 VSS INVR03
* cell instance $100283 r0 *1 1600.09,4366.3
X$100283 \$18 \$11160 \$11163 VSS INVR02
* cell instance $100284 r0 *1 1616.89,4366.3
X$100284 \$18 \$11161 \$4800 VSS INVR03
* cell instance $100288 r0 *1 1649.06,4366.3
X$100288 \$18 \$11163 \$11164 VSS INVR03
* cell instance $100290 r0 *1 1665.86,4366.3
X$100290 \$18 \$12037 \$9486 \$11705 \$11361 VSS NND300
* cell instance $100298 r0 *1 1734.44,4366.3
X$100298 \$18 \$9327 \$11122 VSS INVR06
* cell instance $100300 r0 *1 1818.45,4366.3
X$100300 \$18 \$11578 \$11365 VSS INVR02
* cell instance $100316 r0 *1 1946.43,4366.3
X$100316 \$18 \$10651 \$10825 VSS INVR02
* cell instance $100318 r0 *1 1963.23,4366.3
X$100318 \$18 \$10825 \$11170 VSS INVR02
* cell instance $100322 r0 *1 1994.39,4366.3
X$100322 \$18 \$10821 \$11172 \$11171 VSS AND201
* cell instance $100323 m90 *1 2138.16,4366.3
X$100323 \$11171 \$11178 \$10605 \$18 VSS NND201
* cell instance $100327 r0 *1 2153.03,4366.3
X$100327 \$18 \$10612 \$11179 VSS INVR03
* cell instance $100328 r0 *1 2171.4,4366.3
X$100328 \$11179 \$11181 \$18 \$11180 VSS OR2101
* cell instance $100330 r0 *1 2192.4,4366.3
X$100330 \$11182 \$18 \$9686 VSS INVR05
* cell instance $100332 r0 *1 2227.64,4366.3
X$100332 \$10829 \$11181 \$10830 \$18 VSS NND201
* cell instance $100336 r0 *1 2254.67,4366.3
X$100336 \$11184 \$18 \$11183 \$10436 \$11103 VSS AND301
* cell instance $100339 m90 *1 2320.08,4366.3
X$100339 \$18 \$11185 \$10624 \$11022 VSS AND201
* cell instance $100341 r0 *1 2325.86,4366.3
X$100341 \$18 \$11719 \$11022 VSS INVR03
* cell instance $100345 m90 *1 2379.18,4366.3
X$100345 \$18 \$11187 \$9690 VSS INVR06
* cell instance $100349 m90 *1 2409.19,4366.3
X$100349 \$18 \$11189 \$10435 VSS INVR03
* cell instance $100351 m90 *1 2439.2,4366.3
X$100351 \$18 \$11375 \$10849 VSS INVR06
* cell instance $100354 m90 *1 2469.2,4366.3
X$100354 \$18 \$10842 \$10054 VSS INVR02
* cell instance $100357 r0 *1 2474,4366.3
X$100357 \$10842 \$18 \$7071 \$8597 \$10842 VSS ADNR01
* cell instance $100358 r0 *1 2499.2,4366.3
X$100358 \$11378 \$18 \$11233 VSS INVR05
* cell instance $100362 m90 *1 2553.15,4366.3
X$100362 \$18 \$11192 \$10853 VSS INVR02
* cell instance $100363 m90 *1 2586.76,4366.3
X$100363 \$11189 \$18 \$11194 \$11193 VSS NOR201
* cell instance $100364 m90 *1 2603.56,4366.3
X$100364 \$18 \$11515 \$7288 VSS INVR02
* cell instance $100366 m90 *1 2630.16,4366.3
X$100366 \$18 \$11515 \$11196 \$11030 VSS AND201
* cell instance $100367 r0 *1 2630.16,4366.3
X$100367 \$18 \$11197 \$11031 VSS INVR03
* cell instance $100370 r0 *1 2654.49,4366.3
X$100370 \$18 \$10625 \$11198 VSS INVR03
* cell instance $100372 r0 *1 2671.3,4366.3
X$100372 \$18 \$11199 \$11200 VSS INVR03
* cell instance $100373 r0 *1 2688.11,4366.3
X$100373 \$18 \$11201 \$11031 VSS INVR06
* cell instance $100374 r0 *1 2717.51,4366.3
X$100374 \$18 \$11198 \$11315 VSS INVR03
* cell instance $100376 r0 *1 2737.93,4366.3
X$100376 \$18 \$11203 \$11315 VSS INVR04
* cell instance $100380 m90 *1 2791.26,4366.3
X$100380 \$11206 \$10634 \$18 \$11201 VSS OR2101
* cell instance $100383 m90 *1 2813.37,4366.3
X$100383 \$18 \$8212 \$10636 VSS INVR02
* cell instance $100388 m90 *1 2844.52,4366.3
X$100388 \$8212 \$10067 \$10061 \$18 VSS NND201
* cell instance $100391 m90 *1 2868.07,4366.3
X$100391 \$18 \$11211 \$10633 VSS INVR02
* cell instance $100395 r0 *1 2883.58,4366.3
X$100395 \$10668 \$18 \$11034 VSS INVR05
* cell instance $100397 r0 *1 2908.78,4366.3
X$100397 \$18 \$9790 \$11034 VSS INVR02
* cell instance $100401 r0 *1 2940.28,4366.3
X$100401 \$18 \$8212 \$11215 VSS INVR03
* cell instance $100402 m90 *1 2973.88,4366.3
X$100402 \$18 \$11529 \$10640 VSS INVR02
* cell instance $100404 m90 *1 3000.21,4366.3
X$100404 \$18 \$11390 \$11529 VSS INVR02
* cell instance $100410 r0 *1 3061.22,4366.3
X$100410 \$18 \$10644 \$11220 VSS INVR02
* cell instance $100413 m90 *1 3108.72,4366.3
X$100413 \$18 \$11086 \$8215 \$8457 VSS AND201
* cell instance $100416 r0 *1 3115.01,4366.3
X$100416 \$18 \$8617 \$11224 VSS INVR02
* cell instance $100421 r0 *1 3147.66,4366.3
X$100421 \$18 \$11199 \$11392 VSS INVR02
* cell instance $100422 r0 *1 3165.61,4366.3
X$100422 \$18 \$9931 \$10652 VSS INVR03
* cell instance $100426 m90 *1 3213.92,4366.3
X$100426 \$11225 \$18 \$11035 VSS INVR05
* cell instance $100427 r0 *1 3213.92,4366.3
X$100427 \$18 \$11226 \$10653 VSS INVR06
* cell instance $100428 m90 *1 3264.92,4366.3
X$100428 \$11228 \$11035 \$18 \$8889 VSS OR2101
* cell instance $100434 r0 *1 3305.71,4366.3
X$100434 \$18 \$9030 \$11229 VSS INVR02
* cell instance $100444 m90 *1 3408.32,4366.3
X$100444 \$18 \$7719 \$11230 VSS INVR02
* cell instance $100471 m90 *1 3636.74,4366.3
X$100471 \$18 \$9690 \$6061 VSS INVR06
* cell instance $100488 r0 *1 3757.35,4366.3
X$100488 \$18 \$11233 \$11232 VSS INVR06
* cell instance $100558 r0 *1 4330.48,4366.3
X$100558 \$8743 \$11400 \$I331272 \$11235 \$18 VSS DFFL11
* cell instance $100560 r0 *1 4414.48,4366.3
X$100560 \$18 \$11235 \$11236 VSS INVR02
* cell instance $100566 r0 *1 4463,4366.3
X$100566 \$18 \$10095 \$10674 VSS INVR03
* cell instance $100571 r0 *1 4500.09,4366.3
X$100571 \$18 \$11238 \$10673 \$11237 VSS AND201
* cell instance $100578 r0 *1 4567.57,4366.3
X$100578 \$8743 \$11238 \$I331277 \$11240 \$18 VSS DFFL11
* cell instance $100584 r0 *1 4692.52,4366.3
X$100584 \$18 \$11240 \$11241 VSS INVR02
* cell instance $100586 m90 *1 4815.61,4366.3
X$100586 \$8743 \$10677 \$10678 \$I331489 \$11039 \$18 VSS DFCL11
* cell instance $100588 r0 *1 4815.61,4366.3
X$100588 \$18 \$11039 \$11244 VSS INVR02
* cell instance $100592 r0 *1 4847.68,4366.3
X$100592 \$18 \$11245 \$11556 VSS INVR02
* cell instance $100596 r0 *1 4871.35,4366.3
X$100596 \$18 \$11556 \$11247 VSS INVR02
* cell instance $100601 r0 *1 4917.86,4366.3
X$100601 \$11246 \$18 \$11594 VSS INVR01
* cell instance $100605 r0 *1 4947.09,4366.3
X$100605 \$11246 \$10867 \$18 \$11247 VSS OR2101
* cell instance $100609 r0 *1 4982.52,4366.3
X$100609 \$18 \$11248 \$11076 VSS INVR02
* cell instance $100612 r0 *1 5010.41,4366.3
X$100612 \$18 \$11076 \$10683 VSS INVR02
* cell instance $100615 m90 *1 5054.34,4366.3
X$100615 \$18 \$10679 \$11251 \$11076 VSS AND201
* cell instance $100616 r0 *1 5054.34,4366.3
X$100616 \$18 \$10111 \$10869 VSS INVR06
* cell instance $100617 m90 *1 5100.54,4366.3
X$100617 \$18 \$11251 \$10463 VSS INVR03
* cell instance $100624 r0 *1 5139.58,4366.3
X$100624 \$18 \$11406 \$10692 VSS INVR02
* cell instance $100629 r0 *1 5171.2,4366.3
X$100629 \$10692 \$10693 \$10106 \$18 VSS XNR201
* cell instance $100630 r0 *1 5209,4366.3
X$100630 \$18 \$9946 \$10693 VSS INVR02
* cell instance $100631 r0 *1 5326.6,4366.3
X$100631 \$18 \$10694 \$10104 VSS INVR02
* cell instance $100637 r0 *1 5413.66,4366.3
X$100637 \$18 \$10107 \$11261 VSS INVR03
* cell instance $100640 r0 *1 5443.66,4366.3
X$100640 \$18 \$7470 \$11263 VSS INVR02
* cell instance $100642 r0 *1 5460.46,4366.3
X$100642 \$18 \$11264 \$10701 VSS INVR03
* cell instance $100643 r0 *1 5477.87,4366.3
X$100643 \$18 \$11263 \$11266 VSS INVR03
* cell instance $100645 r0 *1 5499.28,4366.3
X$100645 \$18 \$11267 \$11268 VSS INVR02
* cell instance $100648 r0 *1 5532.77,4366.3
X$100648 \$18 \$11268 \$9560 VSS INVR03
* cell instance $100663 r0 *1 5657.48,4366.3
X$100663 \$18 \$11269 \$11270 VSS INVR03
* cell instance $100668 m90 *1 5723.73,4366.3
X$100668 \$11271 \$18 \$11272 VSS INVR05
* cell instance $100672 m90 *1 5756.08,4366.3
X$100672 \$18 \$10725 \$11272 VSS INVR02
* cell instance $100675 r0 *1 5766,4366.3
X$100675 \$18 \$9558 \$10877 VSS INVR03
* cell instance $100682 r0 *1 5817.72,4366.3
X$100682 \$18 \$11275 \$11274 VSS INVR03
* cell instance $100684 r0 *1 5836.61,4366.3
X$100684 \$18 \$10725 \$11276 VSS INVR06
* cell instance $100694 r0 *1 5925.42,4366.3
X$100694 \$18 \$11279 \$10877 VSS INVR06
* cell instance $100704 r0 *1 6022.81,4366.3
X$100704 \$18 \$9577 \$11281 VSS INVR03
* cell instance $100706 r0 *1 6039.61,4366.3
X$100706 \$18 \$11282 \$11310 VSS INVR03
* cell instance $100709 r0 *1 6059.58,4366.3
X$100709 \$18 \$10712 \$11310 VSS INVR06
* cell instance $100710 r0 *1 6088.98,4366.3
X$100710 \$11418 \$11287 \$11420 \$10716 \$9577 \$18 VSS AOI401
* cell instance $100711 r0 *1 6135.18,4366.3
X$100711 \$18 \$11284 \$11287 VSS INVR02
* cell instance $100712 r0 *1 6152.95,4366.3
X$100712 \$18 \$9579 \$9954 VSS INVR03
* cell instance $100729 r0 *1 6289.38,4366.3
X$100729 \$18 \$8621 \$11425 VSS INVR02
* cell instance $100732 m90 *1 6332.94,4366.3
X$100732 \$18 \$11049 \$9811 VSS INVR03
* cell instance $100734 r0 *1 6332.94,4366.3
X$100734 \$18 \$11427 \$11049 VSS INVR02
* cell instance $100744 r0 *1 6422.94,4366.3
X$100744 \$18 \$11285 \$11050 VSS INVR03
* cell instance $100746 r0 *1 6439.74,4366.3
X$100746 \$11287 \$10137 \$10719 \$10133 \$9811 \$18 VSS AOI401
* cell instance $100750 m90 *1 6525.67,4366.3
X$100750 \$18 \$11289 \$11051 \$11290 VSS AND201
* cell instance $100751 r0 *1 6525.67,4366.3
X$100751 \$18 \$11291 \$11051 VSS INVR06
* cell instance $100752 r0 *1 6555.07,4366.3
X$100752 \$18 \$11293 \$11292 VSS INVR06
* cell instance $100754 r0 *1 6586.65,4366.3
X$100754 \$8743 \$11294 \$11050 \$I331337 \$11295 \$18 VSS DFCL11
* cell instance $100759 r0 *1 6720.2,4366.3
X$100759 \$18 \$11295 \$11452 VSS INVR02
* cell instance $100760 r0 *1 6737,4366.3
X$100760 \$18 \$11452 \$11051 VSS INVR03
* cell instance $100826 r0 *1 7268.03,4366.3
X$100826 \$18 \$11299 \$11279 VSS INVR06
* cell instance $100829 r0 *1 7309.94,4366.3
X$100829 \$18 \$10724 \$11053 VSS INVR03
* cell instance $100841 r0 *1 7401.79,4366.3
X$100841 \$18 \$11302 \$11053 VSS INVR06
* cell instance $100874 r0 *1 7683.9,4366.3
X$100874 \$11429 \$18 \$11293 VSS INVR05
* cell instance $100903 r0 *1 7934.85,4366.3
X$100903 \$18 \$10145 \$11307 VSS INVR03
* cell instance $100906 r0 *1 7953.75,4366.3
X$100906 \$18 \$11303 \$11307 VSS INVR06
* cell instance $100994 r0 *1 8677.04,4366.3
X$100994 \$18 \$10281 \$10282 VSS INVR03
* cell instance $100997 r0 *1 8696.71,4366.3
X$100997 \$18 \$9596 \$11304 VSS INVR03
* cell instance $100998 r0 *1 8715.61,4366.3
X$100998 \$18 \$11304 \$10891 VSS INVR03
* cell instance $101011 r0 *1 8817.53,4366.3
X$101011 \$18 \$11299 \$11057 VSS INVR02
* cell instance $101020 r0 *1 23.71,4188.9
X$101020 \$18 \$9991 \$9417 VSS INVR03
* cell instance $101023 r0 *1 56.66,4188.9
X$101023 \$18 \$9491 \$8520 VSS INVR06
* cell instance $101025 r0 *1 91.52,4188.9
X$101025 \$18 \$9871 \$9876 VSS INVR03
* cell instance $101027 r0 *1 108.32,4188.9
X$101027 \$18 \$9993 \$9877 VSS INVR03
* cell instance $101028 r0 *1 126.02,4188.9
X$101028 \$18 \$8268 \$9876 VSS INVR06
* cell instance $101029 r0 *1 155.42,4188.9
X$101029 \$18 \$7329 \$9418 VSS INVR03
* cell instance $101030 r0 *1 172.22,4188.9
X$101030 \$18 \$9421 \$8533 VSS INVR02
* cell instance $101031 r0 *1 189.02,4188.9
X$101031 \$18 \$9418 \$9994 VSS INVR02
* cell instance $101033 r0 *1 210.42,4188.9
X$101033 \$9423 \$18 \$9995 VSS INVR01
* cell instance $101043 r0 *1 295.82,4188.9
X$101043 \$18 \$9996 \$9881 VSS INVR06
* cell instance $101044 r0 *1 325.22,4188.9
X$101044 \$18 \$10180 \$9997 VSS INVR06
* cell instance $101045 r0 *1 354.62,4188.9
X$101045 \$18 \$9996 \$9654 VSS INVR02
* cell instance $101046 r0 *1 371.42,4188.9
X$101046 \$9652 \$18 \$9996 VSS INVR01
* cell instance $101049 r0 *1 400.44,4188.9
X$101049 \$18 \$9432 \$9998 VSS INVR02
* cell instance $101052 m90 *1 450.83,4188.9
X$101052 \$18 \$10407 \$8815 VSS INVR03
* cell instance $101053 r0 *1 451.8,4188.9
X$101053 \$9887 \$9824 \$18 \$8819 VSS OR2101
* cell instance $101055 r0 *1 476.31,4188.9
X$101055 \$18 \$8819 \$10000 VSS INVR03
* cell instance $101057 r0 *1 493.11,4188.9
X$101057 \$9887 \$18 \$10001 VSS INVR01
* cell instance $101059 m90 *1 554,4188.9
X$101059 \$9660 \$10003 \$10002 \$10005 \$9824 \$18 VSS AOI401
* cell instance $101060 m90 *1 575,4188.9
X$101060 \$8964 \$10005 \$18 \$9444 VSS OR2101
* cell instance $101061 r0 *1 575.41,4188.9
X$101061 \$18 \$10006 \$10190 VSS INVR02
* cell instance $101062 r0 *1 592.21,4188.9
X$101062 \$9443 \$18 \$10007 VSS INVR01
* cell instance $101063 r0 *1 604.81,4188.9
X$101063 \$8964 \$10009 \$18 \$10003 VSS OR2101
* cell instance $101064 r0 *1 625.81,4188.9
X$101064 \$18 \$6972 \$9894 VSS INVR06
* cell instance $101066 m90 *1 676.23,4188.9
X$101066 \$18 \$10309 \$9299 VSS INVR02
* cell instance $101067 m90 *1 693.03,4188.9
X$101067 \$18 \$10199 \$10309 VSS INVR02
* cell instance $101069 r0 *1 702.5,4188.9
X$101069 \$10199 \$9660 \$9897 \$18 VSS NND201
* cell instance $101072 r0 *1 727.84,4188.9
X$101072 \$8829 \$18 \$9450 VSS INVR05
* cell instance $101073 m90 *1 769.84,4188.9
X$101073 \$18 \$9453 \$9897 VSS INVR02
* cell instance $101076 r0 *1 786.49,4188.9
X$101076 \$18 \$10012 \$10311 VSS INVR02
* cell instance $101077 r0 *1 803.29,4188.9
X$101077 \$18 \$10311 \$8971 VSS INVR03
* cell instance $101078 r0 *1 851.16,4188.9
X$101078 \$10014 \$10016 \$18 \$10015 VSS OR2101
* cell instance $101088 r0 *1 941.23,4188.9
X$101088 \$18 \$10020 \$7505 VSS INVR03
* cell instance $101090 r0 *1 976.67,4188.9
X$101090 \$18 \$6758 \$9457 VSS INVR06
* cell instance $101093 r0 *1 1016.15,4188.9
X$101093 \$18 \$9454 \$9456 VSS INVR02
* cell instance $101096 r0 *1 1046.12,4188.9
X$101096 \$18 \$10023 \$9464 VSS INVR03
* cell instance $101101 r0 *1 1087.55,4188.9
X$101101 \$18 \$9454 \$9467 VSS INVR06
* cell instance $101102 r0 *1 1117.56,4188.9
X$101102 \$18 \$7882 \$9310 VSS INVR06
* cell instance $101105 r0 *1 1159.04,4188.9
X$101105 \$18 \$10026 \$10023 VSS INVR03
* cell instance $101106 r0 *1 1176.44,4188.9
X$101106 \$18 \$10029 \$10028 \$9455 VSS AND201
* cell instance $101108 r0 *1 1210.64,4188.9
X$101108 \$9466 \$18 \$8984 VSS INVR05
* cell instance $101112 r0 *1 1249,4188.9
X$101112 \$18 \$10029 \$9104 VSS INVR03
* cell instance $101116 r0 *1 1279.68,4188.9
X$101116 \$18 \$10032 \$10208 \$8565 VSS AND201
* cell instance $101118 r0 *1 1304.88,4188.9
X$101118 \$18 \$9905 \$10033 VSS INVR02
* cell instance $101119 m90 *1 1356.4,4188.9
X$101119 \$9905 \$18 \$7886 \$10032 VSS NOR201
* cell instance $101124 r0 *1 1370.99,4188.9
X$101124 \$9472 \$9477 \$8570 \$18 VSS NND201
* cell instance $101125 m90 *1 1404.6,4188.9
X$101125 \$18 \$10037 \$10036 VSS INVR03
* cell instance $101126 m90 *1 1417.2,4188.9
X$101126 \$9669 \$18 \$10332 VSS INVR01
* cell instance $101128 m90 *1 1434.25,4188.9
X$101128 \$10332 \$18 \$9487 VSS INVR01
* cell instance $101131 r0 *1 1441.09,4188.9
X$101131 \$18 \$10039 \$9487 VSS INVR02
* cell instance $101140 r0 *1 1515.95,4188.9
X$101140 \$10041 \$18 \$7907 \$9488 VSS NOR201
* cell instance $101146 r0 *1 1587.32,4188.9
X$101146 \$8570 \$18 \$10214 VSS INVR05
* cell instance $101151 r0 *1 1634.11,4188.9
X$101151 \$18 \$9910 \$10042 \$9485 VSS AND201
* cell instance $101153 r0 *1 1659.32,4188.9
X$101153 \$10043 \$18 \$10215 VSS INVR05
* cell instance $101156 r0 *1 1700.71,4188.9
X$101156 \$18 \$7907 \$9316 VSS INVR06
* cell instance $101158 r0 *1 1733.56,4188.9
X$101158 \$18 \$8583 \$10216 VSS INVR02
* cell instance $101160 r0 *1 1750.36,4188.9
X$101160 \$18 \$8583 \$10045 VSS INVR02
* cell instance $101168 r0 *1 1814.57,4188.9
X$101168 \$9495 \$18 \$8756 VSS INVR01
* cell instance $101189 r0 *1 1980.92,4188.9
X$101189 \$9000 \$9501 \$18 \$9108 VSS OR2101
* cell instance $101191 r0 *1 2001.92,4188.9
X$101191 \$18 \$9499 \$8037 VSS INVR03
* cell instance $101192 r0 *1 2018.72,4188.9
X$101192 \$9914 \$18 \$10219 VSS INVR05
* cell instance $101193 r0 *1 2043.92,4188.9
X$101193 \$18 \$10222 \$9914 VSS INVR06
* cell instance $101208 m90 *1 2192.36,4188.9
X$101208 \$18 \$10049 \$10048 VSS INVR03
* cell instance $101215 m90 *1 2253.32,4188.9
X$101215 \$18 \$8669 \$9510 VSS INVR03
* cell instance $101217 m90 *1 2278.46,4188.9
X$101217 \$18 \$10435 \$10050 VSS INVR02
* cell instance $101221 r0 *1 2296.52,4188.9
X$101221 \$18 \$9205 \$9219 VSS INVR02
* cell instance $101222 r0 *1 2313.32,4188.9
X$101222 \$18 \$10224 \$10436 VSS INVR02
* cell instance $101228 m90 *1 2384.82,4188.9
X$101228 \$18 \$10230 \$6655 VSS INVR03
* cell instance $101232 r0 *1 2397.17,4188.9
X$101232 \$18 \$9016 \$8863 VSS INVR06
* cell instance $101233 r0 *1 2428.03,4188.9
X$101233 \$18 \$10054 \$10235 VSS INVR03
* cell instance $101237 r0 *1 2460.93,4188.9
X$101237 \$18 \$7288 \$10842 VSS INVR03
* cell instance $101238 m90 *1 2502.93,4188.9
X$101238 \$7288 \$18 \$9121 VSS INVR05
* cell instance $101242 m90 *1 2534.85,4188.9
X$101242 \$18 \$9524 \$10237 VSS INVR02
* cell instance $101244 r0 *1 2534.99,4188.9
X$101244 \$8872 \$18 \$9123 VSS INVR05
* cell instance $101245 r0 *1 2560.2,4188.9
X$101245 \$9118 \$8212 \$8473 \$18 VSS NND201
* cell instance $101246 r0 *1 2577,4188.9
X$101246 \$9796 \$18 \$9514 VSS INVR01
* cell instance $101249 r0 *1 2600.71,4188.9
X$101249 \$8873 \$7572 \$9798 \$18 VSS NND201
* cell instance $101255 m90 *1 2657.42,4188.9
X$101255 \$18 \$7566 \$9853 VSS INVR03
* cell instance $101257 r0 *1 2657.42,4188.9
X$101257 \$18 \$10058 \$9526 VSS INVR06
* cell instance $101259 r0 *1 2695.81,4188.9
X$101259 \$9853 \$10059 \$18 \$9697 VSS OR2101
* cell instance $101261 r0 *1 2720.32,4188.9
X$101261 \$18 \$10060 \$9697 VSS INVR02
* cell instance $101263 r0 *1 2737.86,4188.9
X$101263 \$9698 \$10061 \$8696 \$18 VSS NND201
* cell instance $101265 r0 *1 2817.67,4188.9
X$101265 \$18 \$10063 \$10064 VSS INVR02
* cell instance $101269 r0 *1 2849.45,4188.9
X$101269 \$10065 \$10382 \$18 \$8779 VSS OR2101
* cell instance $101270 r0 *1 2870.45,4188.9
X$101270 \$18 \$10382 \$10063 VSS INVR02
* cell instance $101274 r0 *1 2917.26,4188.9
X$101274 \$18 \$9939 \$9196 VSS INVR06
* cell instance $101277 r0 *1 2952.92,4188.9
X$101277 \$18 \$8213 \$9930 VSS INVR03
* cell instance $101278 r0 *1 2969.72,4188.9
X$101278 \$18 \$10069 \$9930 VSS INVR06
* cell instance $101279 r0 *1 2999.12,4188.9
X$101279 \$18 \$10060 \$8614 VSS INVR02
* cell instance $101284 m90 *1 3060.81,4188.9
X$101284 \$18 \$10073 \$10072 VSS INVR02
* cell instance $101287 r0 *1 3067.25,4188.9
X$101287 \$10074 \$10075 \$18 \$8618 VSS OR2101
* cell instance $101291 r0 *1 3101.42,4188.9
X$101291 \$18 \$10073 \$9538 VSS INVR06
* cell instance $101292 r0 *1 3132.02,4188.9
X$101292 \$18 \$9837 \$10078 VSS INVR03
* cell instance $101294 r0 *1 3148.82,4188.9
X$101294 \$18 \$9220 \$9931 VSS INVR03
* cell instance $101295 r0 *1 3165.62,4188.9
X$101295 \$18 \$9213 \$9837 VSS INVR03
* cell instance $101298 r0 *1 3192.91,4188.9
X$101298 \$18 \$10081 \$9129 VSS INVR06
* cell instance $101301 r0 *1 3234.64,4188.9
X$101301 \$10083 \$18 \$8618 \$10074 VSS NOR201
* cell instance $101306 r0 *1 3298,4188.9
X$101306 \$18 \$8618 \$9833 VSS INVR02
* cell instance $101311 m90 *1 3364.12,4188.9
X$101311 \$18 \$9545 \$10085 \$10086 VSS AND201
* cell instance $101316 r0 *1 3396.32,4188.9
X$101316 \$9833 \$10085 \$18 \$9937 VSS OR2101
* cell instance $101334 r0 *1 3547.96,4188.9
X$101334 \$18 \$9831 \$10089 VSS INVR03
* cell instance $101337 r0 *1 3577.36,4188.9
X$101337 \$18 \$9549 \$9831 VSS INVR03
* cell instance $101390 r0 *1 4010.39,4188.9
X$101390 \$9133 \$18 \$9939 VSS INVR05
* cell instance $101402 r0 *1 4107.11,4188.9
X$101402 \$18 \$10091 \$10081 VSS INVR06
* cell instance $101408 r0 *1 4167.09,4188.9
X$101408 \$10093 \$18 \$10092 VSS INVR05
* cell instance $101411 r0 *1 4205.91,4188.9
X$101411 \$9556 \$18 \$9532 VSS INVR05
* cell instance $101418 r0 *1 4266.62,4188.9
X$101418 \$10096 \$18 \$10095 VSS INVR01
* cell instance $101420 r0 *1 4279.22,4188.9
X$101420 \$18 \$9551 \$10399 VSS INVR02
* cell instance $101421 r0 *1 4296.02,4188.9
X$101421 \$18 \$10399 \$9703 VSS INVR03
* cell instance $101433 r0 *1 4401.61,4188.9
X$101433 \$18 \$5484 \$10098 VSS INVR02
* cell instance $101435 r0 *1 4426.63,4188.9
X$101435 \$10099 \$18 \$9536 VSS INVR05
* cell instance $101525 r0 *1 5147.05,4188.9
X$101525 \$18 \$10101 \$10091 VSS INVR06
* cell instance $101527 r0 *1 5179.32,4188.9
X$101527 \$18 \$9946 \$10102 VSS INVR02
* cell instance $101531 r0 *1 5221.59,4188.9
X$101531 \$18 \$9553 \$9946 VSS INVR02
* cell instance $101538 r0 *1 5279.66,4188.9
X$101538 \$18 \$10104 \$10105 VSS INVR03
* cell instance $101542 r0 *1 5300.4,4188.9
X$101542 \$18 \$10106 \$10107 VSS INVR02
* cell instance $101549 r0 *1 5359,4188.9
X$101549 \$18 \$9580 \$10108 VSS INVR06
* cell instance $101559 r0 *1 5460.97,4188.9
X$101559 \$18 \$9559 \$9564 VSS INVR03
* cell instance $101560 r0 *1 5479,4188.9
X$101560 \$9555 \$18 \$10111 VSS INVR01
* cell instance $101562 r0 *1 5491.6,4188.9
X$101562 \$18 \$9038 \$10112 VSS INVR02
* cell instance $101564 r0 *1 5513.47,4188.9
X$101564 \$18 \$10111 \$9984 VSS INVR03
* cell instance $101566 r0 *1 5530.27,4188.9
X$101566 \$10114 \$18 \$9984 VSS INVR05
* cell instance $101585 m90 *1 5707.1,4188.9
X$101585 \$18 \$9039 \$9558 VSS INVR03
* cell instance $101587 r0 *1 5716.58,4188.9
X$101587 \$18 \$10115 \$10350 VSS INVR02
* cell instance $101591 r0 *1 5737.21,4188.9
X$101591 \$18 \$10350 \$10116 VSS INVR02
* cell instance $101594 r0 *1 5766.61,4188.9
X$101594 \$18 \$10116 \$9950 VSS INVR03
* cell instance $101606 r0 *1 5871.61,4188.9
X$101606 \$18 \$8890 \$9982 VSS INVR03
* cell instance $101608 r0 *1 5890.51,4188.9
X$101608 \$18 \$10117 \$9982 VSS INVR06
* cell instance $101610 r0 *1 5922.99,4188.9
X$101610 \$18 \$10118 \$10119 VSS INVR02
* cell instance $101616 r0 *1 5962.2,4188.9
X$101616 \$18 \$10121 \$10120 VSS INVR06
* cell instance $101617 r0 *1 5991.6,4188.9
X$101617 \$9713 \$18 \$10122 VSS INVR05
* cell instance $101619 r0 *1 6021.68,4188.9
X$101619 \$8743 \$10123 \$9954 \$I331351 \$9573 \$18 VSS DFCL11
* cell instance $101624 r0 *1 6149.99,4188.9
X$101624 \$18 \$9574 \$9576 VSS INVR02
* cell instance $101627 r0 *1 6169.75,4188.9
X$101627 \$18 \$10121 \$9956 VSS INVR03
* cell instance $101632 r0 *1 6202.53,4188.9
X$101632 \$18 \$10127 \$9582 VSS INVR02
* cell instance $101633 r0 *1 6220.65,4188.9
X$101633 \$9578 \$8895 \$10127 \$9956 \$9811 \$18 VSS AOI401
* cell instance $101636 r0 *1 6271.66,4188.9
X$101636 \$18 \$10482 \$10132 VSS INVR03
* cell instance $101641 r0 *1 6322.04,4188.9
X$101641 \$18 \$8895 \$9812 VSS INVR03
* cell instance $101646 r0 *1 6363.76,4188.9
X$101646 \$9581 \$10135 \$10313 \$10133 \$9811 \$18 VSS AOI401
* cell instance $101647 r0 *1 6409.96,4188.9
X$101647 \$18 \$10313 \$9586 VSS INVR03
* cell instance $101648 r0 *1 6426.76,4188.9
X$101648 \$10137 \$18 \$10136 VSS INVR01
* cell instance $101650 r0 *1 6449.04,4188.9
X$101650 \$8743 \$9044 \$9820 \$I331355 \$9819 \$18 VSS DFCL11
* cell instance $101652 r0 *1 6549.84,4188.9
X$101652 \$18 \$10138 \$9812 VSS INVR06
* cell instance $101655 r0 *1 6583.17,4188.9
X$101655 \$18 \$9819 \$10140 VSS INVR02
* cell instance $101660 r0 *1 6623.25,4188.9
X$101660 \$18 \$10140 \$10141 VSS INVR03
* cell instance $101695 r0 *1 6904.28,4188.9
X$101695 \$10143 \$18 \$10117 VSS INVR05
* cell instance $101820 r0 *1 7915.95,4188.9
X$101820 \$18 \$10143 \$9971 VSS INVR03
* cell instance $101822 r0 *1 7934.85,4188.9
X$101822 \$18 \$10145 \$9971 VSS INVR06
* cell instance $101876 r0 *1 8382.65,4188.9
X$101876 \$18 \$10138 \$9814 VSS INVR03
* cell instance $101907 r0 *1 8640.44,4188.9
X$101907 \$18 \$9594 \$9815 VSS INVR03
* cell instance $101910 r0 *1 8670.44,4188.9
X$101910 \$18 \$10280 \$10281 VSS INVR02
* cell instance $101936 r0 *1 8870.4,4188.9
X$101936 \$18 \$9814 \$10147 VSS INVR02
* device instance $1 r180 *1 4647.22,1830.55 N
M$1 VSS \$I332133 \$I332134 VSS N L=1.2U W=6U AS=22.5P AD=13.2375P PS=19.5U
+ PD=11.4U
* device instance $2 r180 *1 4642.12,1829.8 N
M$2 \$1893 \$I332134 VSS VSS N L=1.2U W=7.5U AS=13.2375P AD=27.75P PS=11.4U
+ PD=22.4U
* device instance $3 r180 *1 4684.62,1829.45 N
M$3 \$I332137 \$1999 VSS VSS N L=1.2U W=6.5U AS=24.05P AD=6.5P PS=20.4U PD=8.5U
* device instance $4 r180 *1 4681.42,1829.45 N
M$4 \$I332138 \$1999 \$I332137 VSS N L=1.2U W=6.5U AS=6.5P AD=6.5P PS=8.5U
+ PD=8.5U
* device instance $5 r180 *1 4678.22,1829.45 N
M$5 \$I332140 \$2496 \$I332138 VSS N L=1.2U W=6.5U AS=6.5P AD=24.05P PS=8.5U
+ PD=20.4U
* device instance $6 r180 *1 4662.77,1829.7 N
M$6 \$I332133 \$I332139 VSS VSS N L=1.2U W=7U AS=25.9P AD=14.7P PS=21.4U
+ PD=11.2U
* device instance $7 r180 *1 4657.37,1829.7 N
M$7 VSS \$I332140 \$I332133 VSS N L=1.2U W=7U AS=14.7P AD=25.9P PS=11.2U
+ PD=21.4U
* device instance $8 r180 *1 4703.07,1829.45 N
M$8 \$I332135 \$2430 VSS VSS N L=1.2U W=6.5U AS=24.05P AD=6.5P PS=20.4U PD=8.5U
* device instance $9 r180 *1 4699.87,1829.45 N
M$9 \$I332136 \$2429 \$I332135 VSS N L=1.2U W=6.5U AS=6.5P AD=7.475P PS=8.5U
+ PD=8.8U
* device instance $10 r180 *1 4696.37,1829.45 N
M$10 \$I332139 \$2428 \$I332136 VSS N L=1.2U W=6.5U AS=7.475P AD=24.05P PS=8.8U
+ PD=20.4U
* device instance $11 r180 *1 4647.62,1808.05 P
M$11 \$18 \$I332133 \$I332134 \$18 P L=1.5U W=11U AS=40.7P AD=26P PS=29.4U
+ PD=19U
* device instance $12 r180 *1 4642.12,1806.05 P
M$12 \$1893 \$I332134 \$18 \$18 P L=1.5U W=15U AS=26P AD=55.5P PS=19U PD=37.4U
* device instance $13 r180 *1 4661.62,1807.05 P
M$13 \$I332141 \$I332139 \$18 \$18 P L=1.5U W=13U AS=48.1P AD=13P PS=33.4U
+ PD=15U
* device instance $14 r180 *1 4658.12,1807.05 P
M$14 \$I332133 \$I332140 \$I332141 \$18 P L=1.5U W=13U AS=13P AD=48.1P PS=15U
+ PD=33.4U
* device instance $15 r180 *1 4702.87,1807.8 P
M$15 \$18 \$2430 \$I332139 \$18 P L=1.5U W=11.5U AS=43.125P AD=22.425P PS=30.5U
+ PD=15.4U
* device instance $16 r180 *1 4697.47,1807.8 P
M$16 \$I332139 \$2429 \$18 \$18 P L=1.5U W=11.5U AS=22.425P AD=22.425P PS=15.4U
+ PD=15.4U
* device instance $17 r180 *1 4692.07,1807.8 P
M$17 \$18 \$2428 \$I332139 \$18 P L=1.5U W=11.5U AS=22.425P AD=22.425P PS=15.4U
+ PD=15.4U
* device instance $18 r180 *1 4686.67,1807.8 P
M$18 \$I332140 \$1999 \$18 \$18 P L=1.5U W=23U AS=44.85P AD=44.85P PS=30.8U
+ PD=30.8U
* device instance $20 r180 *1 4675.87,1807.8 P
M$20 \$I332140 \$2496 \$18 \$18 P L=1.5U W=11.5U AS=22.425P AD=47.725P PS=15.4U
+ PD=31.3U
* device instance $21 r180 *1 4346.47,2362.15 N
M$21 VSS \$2857 \$I332143 VSS N L=1.2U W=8.5U AS=31.45P AD=16.575P PS=24.4U
+ PD=12.4U
* device instance $22 r180 *1 4341.37,2362.15 N
M$22 \$I332143 \$2496 VSS VSS N L=1.2U W=8.5U AS=16.575P AD=16.575P PS=12.4U
+ PD=12.4U
* device instance $23 r180 *1 4336.27,2362.15 N
M$23 VSS \$2558 \$I332143 VSS N L=1.2U W=8.5U AS=16.575P AD=31.45P PS=12.4U
+ PD=24.4U
* device instance $24 r180 *1 4297.77,2362.15 N
M$24 \$3263 \$I332145 VSS VSS N L=1.2U W=7.5U AS=27.75P AD=27.75P PS=22.4U
+ PD=22.4U
* device instance $25 r180 *1 4326.17,2362.15 N
M$25 \$I332146 \$I332143 \$I332144 VSS N L=1.2U W=5.5U AS=20.35P AD=4.125P
+ PS=18.4U PD=7U
* device instance $26 r180 *1 4323.47,2362.15 N
M$26 VSS \$I332142 \$I332146 VSS N L=1.2U W=5.5U AS=4.125P AD=13.4P PS=7U
+ PD=10.7U
* device instance $27 r180 *1 4318.07,2361.65 N
M$27 \$I332142 \$3176 VSS VSS N L=1.2U W=6.5U AS=13.4P AD=12.675P PS=10.7U
+ PD=10.4U
* device instance $28 r180 *1 4312.97,2361.65 N
M$28 VSS \$3370 \$I332142 VSS N L=1.2U W=6.5U AS=12.675P AD=12.675P PS=10.4U
+ PD=10.4U
* device instance $29 r180 *1 4307.87,2361.65 N
M$29 \$I332145 \$I332144 VSS VSS N L=1.2U W=6.5U AS=12.675P AD=24.05P PS=10.4U
+ PD=20.4U
* device instance $30 r180 *1 4303.62,2340.2 P
M$30 \$I332145 \$I332144 \$18 \$18 P L=1.5U W=11U AS=31.425P AD=40.7P PS=19.7U
+ PD=29.4U
* device instance $31 r180 *1 4297.92,2340.95 P
M$31 \$3263 \$I332145 \$18 \$18 P L=1.5U W=15.5U AS=31.425P AD=57.35P PS=19.7U
+ PD=38.4U
* device instance $32 r180 *1 4346.32,2342.45 P
M$32 \$I332148 \$2857 \$I332143 \$18 P L=1.5U W=12.5U AS=46.25P AD=12.5P
+ PS=32.4U PD=14.5U
* device instance $33 r180 *1 4342.82,2342.45 P
M$33 \$I332147 \$2496 \$I332148 \$18 P L=1.5U W=12.5U AS=12.5P AD=11.25P
+ PS=14.5U PD=14.3U
* device instance $34 r180 *1 4339.52,2342.45 P
M$34 \$18 \$2558 \$I332147 \$18 P L=1.5U W=12.5U AS=11.25P AD=26.25P PS=14.3U
+ PD=16.9U
* device instance $35 r180 *1 4333.62,2339.95 P
M$35 \$I332144 \$I332143 \$18 \$18 P L=1.5U W=7.5U AS=26.25P AD=17.625P
+ PS=16.9U PD=12.2U
* device instance $36 r180 *1 4327.42,2339.95 P
M$36 \$I332144 \$I332142 \$18 \$18 P L=1.5U W=7.5U AS=40.35P AD=17.625P
+ PS=18.1U PD=12.2U
* device instance $37 r180 *1 4317.32,2340.95 P
M$37 \$I332149 \$3176 \$18 \$18 P L=1.5U W=9.5U AS=40.35P AD=7.125P PS=18.1U
+ PD=11U
* device instance $38 r180 *1 4314.32,2340.95 P
M$38 \$I332142 \$3370 \$I332149 \$18 P L=1.5U W=9.5U AS=7.125P AD=35.15P PS=11U
+ PD=26.4U
* device instance $39 m0 *1 547.22,5379.3 N
M$39 \$I332150 \$16994 VSS VSS N L=1.2U W=2.5U AS=19.2175P AD=14.2P PS=14.25U
+ PD=15.4U
* device instance $40 m0 *1 552.62,5379.225 N
M$40 \$16995 \$I332150 VSS VSS N L=1.2U W=10.05U AS=19.2175P AD=37.6875P
+ PS=14.25U PD=27.6U
* device instance $41 m0 *1 546.87,5359.15 P
M$41 \$I332150 \$16994 \$18 \$18 P L=1.5U W=4U AS=28.75P AD=14.8P PS=19.2U
+ PD=15.4U
* device instance $42 m0 *1 552.57,5359.15 P
M$42 \$16995 \$I332150 \$18 \$18 P L=1.5U W=15U AS=28.75P AD=55.5P PS=19.2U
+ PD=37.4U
* device instance $43 m0 *1 2313.55,3605.3 N
M$43 \$I332151 \$6652 VSS VSS N L=1.2U W=2.5U AS=19.2175P AD=14.2P PS=14.25U
+ PD=15.4U
* device instance $44 m0 *1 2318.95,3605.225 N
M$44 \$7192 \$I332151 VSS VSS N L=1.2U W=10.05U AS=19.2175P AD=37.6875P
+ PS=14.25U PD=27.6U
* device instance $45 m0 *1 2313.2,3585.15 P
M$45 \$I332151 \$6652 \$18 \$18 P L=1.5U W=4U AS=28.75P AD=14.8P PS=19.2U
+ PD=15.4U
* device instance $46 m0 *1 2318.9,3585.15 P
M$46 \$7192 \$I332151 \$18 \$18 P L=1.5U W=15U AS=28.75P AD=55.5P PS=19.2U
+ PD=37.4U
* device instance $47 r0 *1 2107.75,4022.9 N
M$47 \$I332152 \$8184 VSS VSS N L=1.2U W=2.5U AS=19.2175P AD=14.2P PS=14.25U
+ PD=15.4U
* device instance $48 r0 *1 2113.15,4022.975 N
M$48 \$8942 \$I332152 VSS VSS N L=1.2U W=10.05U AS=19.2175P AD=37.6875P
+ PS=14.25U PD=27.6U
* device instance $49 r0 *1 2107.4,4043.05 P
M$49 \$I332152 \$8184 \$18 \$18 P L=1.5U W=4U AS=28.75P AD=14.8P PS=19.2U
+ PD=15.4U
* device instance $50 r0 *1 2113.1,4043.05 P
M$50 \$8942 \$I332152 \$18 \$18 P L=1.5U W=15U AS=28.75P AD=55.5P PS=19.2U
+ PD=37.4U
* device instance $51 r180 *1 255.42,5200.25 N
M$51 \$I332153 \$14579 VSS VSS N L=1.2U W=7U AS=26.25P AD=27.3P PS=21.5U
+ PD=21.8U
* device instance $52 r180 *1 224.77,5200.3 N
M$52 \$15911 \$I332154 VSS VSS N L=1.2U W=7U AS=26.25P AD=25.9P PS=21.5U
+ PD=21.4U
* device instance $53 r180 *1 245.12,5201.3 N
M$53 \$I332154 \$I332153 \$15025 VSS N L=1.2U W=9U AS=33.3P AD=31.05P PS=25.4U
+ PD=15.9U
* device instance $54 r180 *1 237.02,5201.3 N
M$54 \$16074 \$14579 \$I332154 VSS N L=1.2U W=9U AS=31.05P AD=33.3P PS=15.9U
+ PD=25.4U
* device instance $55 r180 *1 255.37,5179.8 P
M$55 \$I332153 \$14579 \$18 \$18 P L=1.5U W=14U AS=54.6P AD=51.8P PS=35.8U
+ PD=35.4U
* device instance $56 r180 *1 244.97,5179.85 P
M$56 \$I332154 \$14579 \$15025 \$18 P L=1.5U W=10.5U AS=38.85P AD=38.775P
+ PS=28.4U PD=18.4U
* device instance $57 r180 *1 236.57,5178.85 P
M$57 \$16074 \$I332153 \$I332154 \$18 P L=1.5U W=10.5U AS=38.775P AD=38.85P
+ PS=18.4U PD=28.4U
* device instance $58 r180 *1 224.67,5182.275 P
M$58 \$15911 \$I332154 \$18 \$18 P L=1.5U W=14.05U AS=51.985P AD=51.985P
+ PS=35.5U PD=35.5U
* device instance $59 r0 *1 6445.08,5089.775 N
M$59 VSS \$I332155 \$15400 VSS N L=1.2U W=25U AS=59.6875P AD=59.6875P PS=50.35U
+ PD=50.35U
* device instance $63 r0 *1 6416.23,5087 N
M$63 VSS \$15711 \$I332155 VSS N L=1.2U W=30U AS=71.625P AD=71.625P PS=56.6U
+ PD=56.6U
* device instance $67 r0 *1 6416.43,5112.05 P
M$67 \$18 \$15711 \$I332155 \$18 P L=1.5U W=60U AS=144P AD=143.25P PS=94.2U
+ PD=94.1U
* device instance $71 r0 *1 6443.98,5110.8 P
M$71 \$18 \$I332155 \$15400 \$18 P L=1.5U W=50U AS=120P AD=119.375P PS=81.7U
+ PD=81.6U
* device instance $75 m0 *1 2980.98,5022.025 N
M$75 VSS \$I332156 \$18 VSS N L=1.2U W=25U AS=59.6875P AD=59.6875P PS=50.35U
+ PD=50.35U
* device instance $79 m0 *1 2952.13,5024.8 N
M$79 VSS \$9691 \$I332156 VSS N L=1.2U W=30U AS=71.625P AD=71.625P PS=56.6U
+ PD=56.6U
* device instance $83 m0 *1 2952.33,4999.75 P
M$83 \$18 \$9691 \$I332156 \$18 P L=1.5U W=60U AS=144P AD=143.25P PS=94.2U
+ PD=94.1U
* device instance $87 m0 *1 2979.88,5001 P
M$87 \$18 \$I332156 \$18 \$18 P L=1.5U W=50U AS=120P AD=119.375P PS=81.7U
+ PD=81.6U
* device instance $91 r0 *1 2797.06,4202.775 N
M$91 VSS \$I332157 \$18 VSS N L=1.2U W=25U AS=59.6875P AD=59.6875P PS=50.35U
+ PD=50.35U
* device instance $95 r0 *1 2768.21,4200 N
M$95 VSS \$9800 \$I332157 VSS N L=1.2U W=30U AS=71.625P AD=71.625P PS=56.6U
+ PD=56.6U
* device instance $99 r0 *1 2768.41,4225.05 P
M$99 \$18 \$9800 \$I332157 \$18 P L=1.5U W=60U AS=144P AD=143.25P PS=94.2U
+ PD=94.1U
* device instance $103 r0 *1 2795.96,4223.8 P
M$103 \$18 \$I332157 \$18 \$18 P L=1.5U W=50U AS=120P AD=119.375P PS=81.7U
+ PD=81.6U
* device instance $107 m0 *1 5312.42,4844.625 N
M$107 VSS \$I332158 \$13777 VSS N L=1.2U W=25U AS=59.6875P AD=59.6875P
+ PS=50.35U PD=50.35U
* device instance $111 m0 *1 5283.57,4847.4 N
M$111 VSS \$13916 \$I332158 VSS N L=1.2U W=30U AS=71.625P AD=71.625P PS=56.6U
+ PD=56.6U
* device instance $115 m0 *1 5283.77,4822.35 P
M$115 \$18 \$13916 \$I332158 \$18 P L=1.5U W=60U AS=144P AD=143.25P PS=94.2U
+ PD=94.1U
* device instance $119 m0 *1 5311.32,4823.6 P
M$119 \$18 \$I332158 \$13777 \$18 P L=1.5U W=50U AS=120P AD=119.375P PS=81.7U
+ PD=81.6U
* device instance $123 m0 *1 5752.68,4844.625 N
M$123 VSS \$I332159 \$10115 VSS N L=1.2U W=25U AS=59.6875P AD=59.6875P
+ PS=50.35U PD=50.35U
* device instance $127 m0 *1 5723.83,4847.4 N
M$127 VSS \$13777 \$I332159 VSS N L=1.2U W=30U AS=71.625P AD=71.625P PS=56.6U
+ PD=56.6U
* device instance $131 m0 *1 5724.03,4822.35 P
M$131 \$18 \$13777 \$I332159 \$18 P L=1.5U W=60U AS=144P AD=143.25P PS=94.2U
+ PD=94.1U
* device instance $135 m0 *1 5751.58,4823.6 P
M$135 \$18 \$I332159 \$10115 \$18 P L=1.5U W=50U AS=120P AD=119.375P PS=81.7U
+ PD=81.6U
* device instance $139 r180 *1 1888.94,5022.025 N
M$139 VSS \$I332160 \$14919 VSS N L=1.2U W=25U AS=59.6875P AD=59.6875P
+ PS=50.35U PD=50.35U
* device instance $143 r180 *1 1917.79,5024.8 N
M$143 VSS \$14614 \$I332160 VSS N L=1.2U W=30U AS=71.625P AD=71.625P PS=56.6U
+ PD=56.6U
* device instance $147 r180 *1 1917.59,4999.75 P
M$147 \$18 \$14614 \$I332160 \$18 P L=1.5U W=60U AS=144P AD=143.25P PS=94.2U
+ PD=94.1U
* device instance $151 r180 *1 1890.04,5001 P
M$151 \$18 \$I332160 \$14919 \$18 P L=1.5U W=50U AS=120P AD=119.375P PS=81.7U
+ PD=81.6U
* device instance $155 m90 *1 151.72,4734.975 N
M$155 VSS \$I332161 \$13838 VSS N L=1.2U W=25U AS=59.6875P AD=59.6875P
+ PS=50.35U PD=50.35U
* device instance $159 m90 *1 180.57,4732.2 N
M$159 VSS \$13514 \$I332161 VSS N L=1.2U W=30U AS=71.625P AD=71.625P PS=56.6U
+ PD=56.6U
* device instance $163 m90 *1 180.37,4757.25 P
M$163 \$18 \$13514 \$I332161 \$18 P L=1.5U W=60U AS=144P AD=143.25P PS=94.2U
+ PD=94.1U
* device instance $167 m90 *1 152.82,4756 P
M$167 \$18 \$I332161 \$13838 \$18 P L=1.5U W=50U AS=120P AD=119.375P PS=81.7U
+ PD=81.6U
* device instance $171 r0 *1 1638.16,4734.975 N
M$171 VSS \$I332162 \$13568 VSS N L=1.2U W=25U AS=59.6875P AD=59.6875P
+ PS=50.35U PD=50.35U
* device instance $175 r0 *1 1609.31,4732.2 N
M$175 VSS \$13700 \$I332162 VSS N L=1.2U W=30U AS=71.625P AD=71.625P PS=56.6U
+ PD=56.6U
* device instance $179 r0 *1 1609.51,4757.25 P
M$179 \$18 \$13700 \$I332162 \$18 P L=1.5U W=60U AS=144P AD=143.25P PS=94.2U
+ PD=94.1U
* device instance $183 r0 *1 1637.06,4756 P
M$183 \$18 \$I332162 \$13568 \$18 P L=1.5U W=50U AS=120P AD=119.375P PS=81.7U
+ PD=81.6U
* device instance $187 r0 *1 1730.56,4734.975 N
M$187 VSS \$I332163 \$12912 VSS N L=1.2U W=25U AS=59.6875P AD=59.6875P
+ PS=50.35U PD=50.35U
* device instance $191 r0 *1 1701.71,4732.2 N
M$191 VSS \$13568 \$I332163 VSS N L=1.2U W=30U AS=71.625P AD=71.625P PS=56.6U
+ PD=56.6U
* device instance $195 r0 *1 1701.91,4757.25 P
M$195 \$18 \$13568 \$I332163 \$18 P L=1.5U W=60U AS=144P AD=143.25P PS=94.2U
+ PD=94.1U
* device instance $199 r0 *1 1729.46,4756 P
M$199 \$18 \$I332163 \$12912 \$18 P L=1.5U W=50U AS=120P AD=119.375P PS=81.7U
+ PD=81.6U
* device instance $203 r0 *1 1890.82,4734.975 N
M$203 VSS \$I332164 \$13575 VSS N L=1.2U W=25U AS=59.6875P AD=59.6875P
+ PS=50.35U PD=50.35U
* device instance $207 r0 *1 1861.97,4732.2 N
M$207 VSS \$12911 \$I332164 VSS N L=1.2U W=30U AS=71.625P AD=71.625P PS=56.6U
+ PD=56.6U
* device instance $211 r0 *1 1862.17,4757.25 P
M$211 \$18 \$12911 \$I332164 \$18 P L=1.5U W=60U AS=144P AD=143.25P PS=94.2U
+ PD=94.1U
* device instance $215 r0 *1 1889.72,4756 P
M$215 \$18 \$I332164 \$13575 \$18 P L=1.5U W=50U AS=120P AD=119.375P PS=81.7U
+ PD=81.6U
* device instance $219 r0 *1 2011.73,4734.975 N
M$219 VSS \$I332165 \$12910 VSS N L=1.2U W=25U AS=59.6875P AD=59.6875P
+ PS=50.35U PD=50.35U
* device instance $223 r0 *1 1982.88,4732.2 N
M$223 VSS \$12913 \$I332165 VSS N L=1.2U W=30U AS=71.625P AD=71.625P PS=56.6U
+ PD=56.6U
* device instance $227 r0 *1 1983.08,4757.25 P
M$227 \$18 \$12913 \$I332165 \$18 P L=1.5U W=60U AS=144P AD=143.25P PS=94.2U
+ PD=94.1U
* device instance $231 r0 *1 2010.63,4756 P
M$231 \$18 \$I332165 \$12910 \$18 P L=1.5U W=50U AS=120P AD=119.375P PS=81.7U
+ PD=81.6U
* device instance $235 r0 *1 279.76,5089.775 N
M$235 VSS \$I332166 \$15354 VSS N L=1.2U W=25U AS=59.6875P AD=59.6875P
+ PS=50.35U PD=50.35U
* device instance $239 r0 *1 250.91,5087 N
M$239 VSS \$14440 \$I332166 VSS N L=1.2U W=30U AS=71.625P AD=71.625P PS=56.6U
+ PD=56.6U
* device instance $243 r0 *1 251.11,5112.05 P
M$243 \$18 \$14440 \$I332166 \$18 P L=1.5U W=60U AS=144P AD=143.25P PS=94.2U
+ PD=94.1U
* device instance $247 r0 *1 278.66,5110.8 P
M$247 \$18 \$I332166 \$15354 \$18 P L=1.5U W=50U AS=120P AD=119.375P PS=81.7U
+ PD=81.6U
* device instance $251 r0 *1 5998.29,5089.775 N
M$251 VSS \$I332167 \$11969 VSS N L=1.2U W=25U AS=59.6875P AD=59.6875P
+ PS=50.35U PD=50.35U
* device instance $255 r0 *1 5969.44,5087 N
M$255 VSS \$15400 \$I332167 VSS N L=1.2U W=30U AS=71.625P AD=71.625P PS=56.6U
+ PD=56.6U
* device instance $259 r0 *1 5969.64,5112.05 P
M$259 \$18 \$15400 \$I332167 \$18 P L=1.5U W=60U AS=144P AD=143.25P PS=94.2U
+ PD=94.1U
* device instance $263 r0 *1 5997.19,5110.8 P
M$263 \$18 \$I332167 \$11969 \$18 P L=1.5U W=50U AS=120P AD=119.375P PS=81.7U
+ PD=81.6U
* device instance $267 m90 *1 105.81,3670.575 N
M$267 VSS \$I332168 \$7470 VSS N L=1.2U W=25U AS=59.6875P AD=59.6875P PS=50.35U
+ PD=50.35U
* device instance $271 m90 *1 134.66,3667.8 N
M$271 VSS \$7471 \$I332168 VSS N L=1.2U W=30U AS=71.625P AD=71.625P PS=56.6U
+ PD=56.6U
* device instance $275 m90 *1 134.46,3692.85 P
M$275 \$18 \$7471 \$I332168 \$18 P L=1.5U W=60U AS=144P AD=143.25P PS=94.2U
+ PD=94.1U
* device instance $279 m90 *1 106.91,3691.6 P
M$279 \$18 \$I332168 \$7470 \$18 P L=1.5U W=50U AS=120P AD=119.375P PS=81.7U
+ PD=81.6U
* device instance $283 r0 *1 173.81,3670.575 N
M$283 VSS \$I332169 \$7328 VSS N L=1.2U W=25U AS=59.6875P AD=59.6875P PS=50.35U
+ PD=50.35U
* device instance $287 r0 *1 144.96,3667.8 N
M$287 VSS \$7472 \$I332169 VSS N L=1.2U W=30U AS=71.625P AD=71.625P PS=56.6U
+ PD=56.6U
* device instance $291 r0 *1 145.16,3692.85 P
M$291 \$18 \$7472 \$I332169 \$18 P L=1.5U W=60U AS=144P AD=143.25P PS=94.2U
+ PD=94.1U
* device instance $295 r0 *1 172.71,3691.6 P
M$295 \$18 \$I332169 \$7328 \$18 P L=1.5U W=50U AS=120P AD=119.375P PS=81.7U
+ PD=81.6U
* device instance $299 r0 *1 1359.88,3670.575 N
M$299 VSS \$I332170 \$7518 VSS N L=1.2U W=25U AS=59.6875P AD=59.6875P PS=50.35U
+ PD=50.35U
* device instance $303 r0 *1 1331.03,3667.8 N
M$303 VSS \$7517 \$I332170 VSS N L=1.2U W=30U AS=71.625P AD=71.625P PS=56.6U
+ PD=56.6U
* device instance $307 r0 *1 1331.23,3692.85 P
M$307 \$18 \$7517 \$I332170 \$18 P L=1.5U W=60U AS=144P AD=143.25P PS=94.2U
+ PD=94.1U
* device instance $311 r0 *1 1358.78,3691.6 P
M$311 \$18 \$I332170 \$7518 \$18 P L=1.5U W=50U AS=120P AD=119.375P PS=81.7U
+ PD=81.6U
* device instance $315 m90 *1 2470.19,3670.575 N
M$315 VSS \$I332171 \$7564 VSS N L=1.2U W=25U AS=59.6875P AD=59.6875P PS=50.35U
+ PD=50.35U
* device instance $319 m90 *1 2499.04,3667.8 N
M$319 VSS \$6917 \$I332171 VSS N L=1.2U W=30U AS=71.625P AD=71.625P PS=56.6U
+ PD=56.6U
* device instance $323 m90 *1 2498.84,3692.85 P
M$323 \$18 \$6917 \$I332171 \$18 P L=1.5U W=60U AS=144P AD=143.25P PS=94.2U
+ PD=94.1U
* device instance $327 m90 *1 2471.29,3691.6 P
M$327 \$18 \$I332171 \$7564 \$18 P L=1.5U W=50U AS=120P AD=119.375P PS=81.7U
+ PD=81.6U
* device instance $331 m90 *1 1219.47,2960.975 N
M$331 VSS \$I332172 \$4980 VSS N L=1.2U W=25U AS=59.6875P AD=59.6875P PS=50.35U
+ PD=50.35U
* device instance $335 m90 *1 1248.32,2958.2 N
M$335 VSS \$5048 \$I332172 VSS N L=1.2U W=30U AS=71.625P AD=71.625P PS=56.6U
+ PD=56.6U
* device instance $339 m90 *1 1248.12,2983.25 P
M$339 \$18 \$5048 \$I332172 \$18 P L=1.5U W=60U AS=144P AD=143.25P PS=94.2U
+ PD=94.1U
* device instance $343 m90 *1 1220.57,2982 P
M$343 \$18 \$I332172 \$4980 \$18 P L=1.5U W=50U AS=120P AD=119.375P PS=81.7U
+ PD=81.6U
* device instance $347 m0 *1 4555.36,8392.625 N
M$347 VSS \$I332173 \$20184 VSS N L=1.2U W=25U AS=59.6875P AD=59.6875P
+ PS=50.35U PD=50.35U
* device instance $351 m0 *1 4526.51,8395.4 N
M$351 VSS \$20314 \$I332173 VSS N L=1.2U W=30U AS=71.625P AD=71.625P PS=56.6U
+ PD=56.6U
* device instance $355 m0 *1 4526.71,8370.35 P
M$355 \$18 \$20314 \$I332173 \$18 P L=1.5U W=60U AS=144P AD=143.25P PS=94.2U
+ PD=94.1U
* device instance $359 m0 *1 4554.26,8371.6 P
M$359 \$18 \$I332173 \$20184 \$18 P L=1.5U W=50U AS=120P AD=119.375P PS=81.7U
+ PD=81.6U
* device instance $363 m0 *1 4609.96,8392.625 N
M$363 VSS \$I332174 \$20288 VSS N L=1.2U W=25U AS=59.6875P AD=59.6875P
+ PS=50.35U PD=50.35U
* device instance $367 m0 *1 4581.11,8395.4 N
M$367 VSS \$20194 \$I332174 VSS N L=1.2U W=30U AS=71.625P AD=71.625P PS=56.6U
+ PD=56.6U
* device instance $371 m0 *1 4581.31,8370.35 P
M$371 \$18 \$20194 \$I332174 \$18 P L=1.5U W=60U AS=144P AD=143.25P PS=94.2U
+ PD=94.1U
* device instance $375 m0 *1 4608.86,8371.6 P
M$375 \$18 \$I332174 \$20288 \$18 P L=1.5U W=50U AS=120P AD=119.375P PS=81.7U
+ PD=81.6U
* device instance $379 m0 *1 4855.57,8392.625 N
M$379 VSS \$I332175 \$20194 VSS N L=1.2U W=25U AS=59.6875P AD=59.6875P
+ PS=50.35U PD=50.35U
* device instance $383 m0 *1 4826.72,8395.4 N
M$383 VSS \$20231 \$I332175 VSS N L=1.2U W=30U AS=71.625P AD=71.625P PS=56.6U
+ PD=56.6U
* device instance $387 m0 *1 4826.92,8370.35 P
M$387 \$18 \$20231 \$I332175 \$18 P L=1.5U W=60U AS=144P AD=143.25P PS=94.2U
+ PD=94.1U
* device instance $391 m0 *1 4854.47,8371.6 P
M$391 \$18 \$I332175 \$20194 \$18 P L=1.5U W=50U AS=120P AD=119.375P PS=81.7U
+ PD=81.6U
* device instance $395 m0 *1 5040.37,8392.625 N
M$395 VSS \$I332176 \$20231 VSS N L=1.2U W=25U AS=59.6875P AD=59.6875P
+ PS=50.35U PD=50.35U
* device instance $399 m0 *1 5011.52,8395.4 N
M$399 VSS \$20299 \$I332176 VSS N L=1.2U W=30U AS=71.625P AD=71.625P PS=56.6U
+ PD=56.6U
* device instance $403 m0 *1 5011.72,8370.35 P
M$403 \$18 \$20299 \$I332176 \$18 P L=1.5U W=60U AS=144P AD=143.25P PS=94.2U
+ PD=94.1U
* device instance $407 m0 *1 5039.27,8371.6 P
M$407 \$18 \$I332176 \$20231 \$18 P L=1.5U W=50U AS=120P AD=119.375P PS=81.7U
+ PD=81.6U
* device instance $411 m0 *1 4329.53,8570.025 N
M$411 VSS \$I332177 \$20537 VSS N L=1.2U W=25U AS=59.6875P AD=59.6875P
+ PS=50.35U PD=50.35U
* device instance $415 m0 *1 4300.68,8572.8 N
M$415 VSS \$20281 \$I332177 VSS N L=1.2U W=30U AS=71.625P AD=71.625P PS=56.6U
+ PD=56.6U
* device instance $419 m0 *1 4300.88,8547.75 P
M$419 \$18 \$20281 \$I332177 \$18 P L=1.5U W=60U AS=144P AD=143.25P PS=94.2U
+ PD=94.1U
* device instance $423 m0 *1 4328.43,8549 P
M$423 \$18 \$I332177 \$20537 \$18 P L=1.5U W=50U AS=120P AD=119.375P PS=81.7U
+ PD=81.6U
* device instance $427 r180 *1 4794.7,8570.025 N
M$427 VSS \$I332178 \$20456 VSS N L=1.2U W=25U AS=59.6875P AD=59.6875P
+ PS=50.35U PD=50.35U
* device instance $431 r180 *1 4823.55,8572.8 N
M$431 VSS \$20554 \$I332178 VSS N L=1.2U W=30U AS=71.625P AD=71.625P PS=56.6U
+ PD=56.6U
* device instance $435 r180 *1 4823.35,8547.75 P
M$435 \$18 \$20554 \$I332178 \$18 P L=1.5U W=60U AS=144P AD=143.25P PS=94.2U
+ PD=94.1U
* device instance $439 r180 *1 4795.8,8549 P
M$439 \$18 \$I332178 \$20456 \$18 P L=1.5U W=50U AS=120P AD=119.375P PS=81.7U
+ PD=81.6U
* device instance $443 m0 *1 4862.7,8570.025 N
M$443 VSS \$I332179 \$20455 VSS N L=1.2U W=25U AS=59.6875P AD=59.6875P
+ PS=50.35U PD=50.35U
* device instance $447 m0 *1 4833.85,8572.8 N
M$447 VSS \$20498 \$I332179 VSS N L=1.2U W=30U AS=71.625P AD=71.625P PS=56.6U
+ PD=56.6U
* device instance $451 m0 *1 4834.05,8547.75 P
M$451 \$18 \$20498 \$I332179 \$18 P L=1.5U W=60U AS=144P AD=143.25P PS=94.2U
+ PD=94.1U
* device instance $455 m0 *1 4861.6,8549 P
M$455 \$18 \$I332179 \$20455 \$18 P L=1.5U W=50U AS=120P AD=119.375P PS=81.7U
+ PD=81.6U
* device instance $459 m0 *1 4812.06,8215.225 N
M$459 VSS \$I332180 \$20079 VSS N L=1.2U W=25U AS=59.6875P AD=59.6875P
+ PS=50.35U PD=50.35U
* device instance $463 m0 *1 4783.21,8218 N
M$463 VSS \$20039 \$I332180 VSS N L=1.2U W=30U AS=71.625P AD=71.625P PS=56.6U
+ PD=56.6U
* device instance $467 m0 *1 4783.41,8192.95 P
M$467 \$18 \$20039 \$I332180 \$18 P L=1.5U W=60U AS=144P AD=143.25P PS=94.2U
+ PD=94.1U
* device instance $471 m0 *1 4810.96,8194.2 P
M$471 \$18 \$I332180 \$20079 \$18 P L=1.5U W=50U AS=120P AD=119.375P PS=81.7U
+ PD=81.6U
* device instance $475 m0 *1 651.57,5376.825 N
M$475 VSS \$I332181 \$16997 VSS N L=1.2U W=25U AS=59.6875P AD=59.6875P
+ PS=50.35U PD=50.35U
* device instance $479 m0 *1 622.72,5379.6 N
M$479 VSS \$16943 \$I332181 VSS N L=1.2U W=30U AS=71.625P AD=71.625P PS=56.6U
+ PD=56.6U
* device instance $483 m0 *1 622.92,5354.55 P
M$483 \$18 \$16943 \$I332181 \$18 P L=1.5U W=60U AS=144P AD=143.25P PS=94.2U
+ PD=94.1U
* device instance $487 m0 *1 650.47,5355.8 P
M$487 \$18 \$I332181 \$16997 \$18 P L=1.5U W=50U AS=120P AD=119.375P PS=81.7U
+ PD=81.6U
* device instance $491 m0 *1 1213.49,5199.425 N
M$491 VSS \$I332182 \$15511 VSS N L=1.2U W=25U AS=59.6875P AD=59.6875P
+ PS=50.35U PD=50.35U
* device instance $495 m0 *1 1184.64,5202.2 N
M$495 VSS \$15649 \$I332182 VSS N L=1.2U W=30U AS=71.625P AD=71.625P PS=56.6U
+ PD=56.6U
* device instance $499 m0 *1 1184.84,5177.15 P
M$499 \$18 \$15649 \$I332182 \$18 P L=1.5U W=60U AS=144P AD=143.25P PS=94.2U
+ PD=94.1U
* device instance $503 m0 *1 1212.39,5178.4 P
M$503 \$18 \$I332182 \$15511 \$18 P L=1.5U W=50U AS=120P AD=119.375P PS=81.7U
+ PD=81.6U
* device instance $507 m0 *1 1722.66,5199.425 N
M$507 VSS \$I332183 \$12896 VSS N L=1.2U W=25U AS=59.6875P AD=59.6875P
+ PS=50.35U PD=50.35U
* device instance $511 m0 *1 1693.81,5202.2 N
M$511 VSS \$15520 \$I332183 VSS N L=1.2U W=30U AS=71.625P AD=71.625P PS=56.6U
+ PD=56.6U
* device instance $515 m0 *1 1694.01,5177.15 P
M$515 \$18 \$15520 \$I332183 \$18 P L=1.5U W=60U AS=144P AD=143.25P PS=94.2U
+ PD=94.1U
* device instance $519 m0 *1 1721.56,5178.4 P
M$519 \$18 \$I332183 \$12896 \$18 P L=1.5U W=50U AS=120P AD=119.375P PS=81.7U
+ PD=81.6U
* device instance $523 m0 *1 2416.9,5199.425 N
M$523 VSS \$I332184 \$15536 VSS N L=1.2U W=25U AS=59.6875P AD=59.6875P
+ PS=50.35U PD=50.35U
* device instance $527 m0 *1 2388.05,5202.2 N
M$527 VSS \$12452 \$I332184 VSS N L=1.2U W=30U AS=71.625P AD=71.625P PS=56.6U
+ PD=56.6U
* device instance $531 m0 *1 2388.25,5177.15 P
M$531 \$18 \$12452 \$I332184 \$18 P L=1.5U W=60U AS=144P AD=143.25P PS=94.2U
+ PD=94.1U
* device instance $535 m0 *1 2415.8,5178.4 P
M$535 \$18 \$I332184 \$15536 \$18 P L=1.5U W=50U AS=120P AD=119.375P PS=81.7U
+ PD=81.6U
* device instance $539 m0 *1 588.49,5909.025 N
M$539 VSS \$I332185 \$18922 VSS N L=1.2U W=25U AS=59.6875P AD=59.6875P
+ PS=50.35U PD=50.35U
* device instance $543 m0 *1 559.64,5911.8 N
M$543 VSS \$18358 \$I332185 VSS N L=1.2U W=30U AS=71.625P AD=71.625P PS=56.6U
+ PD=56.6U
* device instance $547 m0 *1 559.84,5886.75 P
M$547 \$18 \$18358 \$I332185 \$18 P L=1.5U W=60U AS=144P AD=143.25P PS=94.2U
+ PD=94.1U
* device instance $551 m0 *1 587.39,5888 P
M$551 \$18 \$I332185 \$18922 \$18 P L=1.5U W=50U AS=120P AD=119.375P PS=81.7U
+ PD=81.6U
* device instance $555 m0 *1 344.06,6086.425 N
M$555 VSS \$I332186 \$19059 VSS N L=1.2U W=25U AS=59.6875P AD=59.6875P
+ PS=50.35U PD=50.35U
* device instance $559 m0 *1 315.21,6089.2 N
M$559 VSS \$18673 \$I332186 VSS N L=1.2U W=30U AS=71.625P AD=71.625P PS=56.6U
+ PD=56.6U
* device instance $563 m0 *1 315.41,6064.15 P
M$563 \$18 \$18673 \$I332186 \$18 P L=1.5U W=60U AS=144P AD=143.25P PS=94.2U
+ PD=94.1U
* device instance $567 m0 *1 342.96,6065.4 P
M$567 \$18 \$I332186 \$19059 \$18 P L=1.5U W=50U AS=120P AD=119.375P PS=81.7U
+ PD=81.6U
* device instance $571 m0 *1 1268.3,6086.425 N
M$571 VSS \$I332187 \$11590 VSS N L=1.2U W=25U AS=59.6875P AD=59.6875P
+ PS=50.35U PD=50.35U
* device instance $575 m0 *1 1239.45,6089.2 N
M$575 VSS \$19178 \$I332187 VSS N L=1.2U W=30U AS=71.625P AD=71.625P PS=56.6U
+ PD=56.6U
* device instance $579 m0 *1 1239.65,6064.15 P
M$579 \$18 \$19178 \$I332187 \$18 P L=1.5U W=60U AS=144P AD=143.25P PS=94.2U
+ PD=94.1U
* device instance $583 m0 *1 1267.2,6065.4 P
M$583 \$18 \$I332187 \$11590 \$18 P L=1.5U W=50U AS=120P AD=119.375P PS=81.7U
+ PD=81.6U
* device instance $587 m0 *1 2014.52,5731.625 N
M$587 VSS \$I332188 \$18101 VSS N L=1.2U W=25U AS=59.6875P AD=59.6875P
+ PS=50.35U PD=50.35U
* device instance $591 m0 *1 1985.67,5734.4 N
M$591 VSS \$18427 \$I332188 VSS N L=1.2U W=30U AS=71.625P AD=71.625P PS=56.6U
+ PD=56.6U
* device instance $595 m0 *1 1985.87,5709.35 P
M$595 \$18 \$18427 \$I332188 \$18 P L=1.5U W=60U AS=144P AD=143.25P PS=94.2U
+ PD=94.1U
* device instance $599 m0 *1 2013.42,5710.6 P
M$599 \$18 \$I332188 \$18101 \$18 P L=1.5U W=50U AS=120P AD=119.375P PS=81.7U
+ PD=81.6U
* device instance $603 r180 *1 1013.23,6441.225 N
M$603 VSS \$I332189 \$19750 VSS N L=1.2U W=25U AS=59.6875P AD=59.6875P
+ PS=50.35U PD=50.35U
* device instance $607 r180 *1 1042.08,6444 N
M$607 VSS \$19813 \$I332189 VSS N L=1.2U W=30U AS=71.625P AD=71.625P PS=56.6U
+ PD=56.6U
* device instance $611 r180 *1 1041.88,6418.95 P
M$611 \$18 \$19813 \$I332189 \$18 P L=1.5U W=60U AS=144P AD=143.25P PS=94.2U
+ PD=94.1U
* device instance $615 r180 *1 1014.33,6420.2 P
M$615 \$18 \$I332189 \$19750 \$18 P L=1.5U W=50U AS=120P AD=119.375P PS=81.7U
+ PD=81.6U
* device instance $619 m0 *1 1413.42,6263.825 N
M$619 VSS \$I332190 \$19764 VSS N L=1.2U W=25U AS=59.6875P AD=59.6875P
+ PS=50.35U PD=50.35U
* device instance $623 m0 *1 1384.57,6266.6 N
M$623 VSS \$19689 \$I332190 VSS N L=1.2U W=30U AS=71.625P AD=71.625P PS=56.6U
+ PD=56.6U
* device instance $627 m0 *1 1384.77,6241.55 P
M$627 \$18 \$19689 \$I332190 \$18 P L=1.5U W=60U AS=144P AD=143.25P PS=94.2U
+ PD=94.1U
* device instance $631 m0 *1 1412.32,6242.8 P
M$631 \$18 \$I332190 \$19764 \$18 P L=1.5U W=50U AS=120P AD=119.375P PS=81.7U
+ PD=81.6U
* device instance $635 m0 *1 562.16,2183.625 N
M$635 VSS \$I332191 \$2924 VSS N L=1.2U W=25U AS=59.6875P AD=59.6875P PS=50.35U
+ PD=50.35U
* device instance $639 m0 *1 533.31,2186.4 N
M$639 VSS \$2970 \$I332191 VSS N L=1.2U W=30U AS=71.625P AD=71.625P PS=56.6U
+ PD=56.6U
* device instance $643 m0 *1 533.51,2161.35 P
M$643 \$18 \$2970 \$I332191 \$18 P L=1.5U W=60U AS=144P AD=143.25P PS=94.2U
+ PD=94.1U
* device instance $647 m0 *1 561.06,2162.6 P
M$647 \$18 \$I332191 \$2924 \$18 P L=1.5U W=50U AS=120P AD=119.375P PS=81.7U
+ PD=81.6U
* device instance $651 m0 *1 4773.26,2006.225 N
M$651 VSS \$I332192 \$1848 VSS N L=1.2U W=25U AS=59.6875P AD=59.6875P PS=50.35U
+ PD=50.35U
* device instance $655 m0 *1 4744.41,2009 N
M$655 VSS \$2518 \$I332192 VSS N L=1.2U W=30U AS=71.625P AD=71.625P PS=56.6U
+ PD=56.6U
* device instance $659 m0 *1 4744.61,1983.95 P
M$659 \$18 \$2518 \$I332192 \$18 P L=1.5U W=60U AS=144P AD=143.25P PS=94.2U
+ PD=94.1U
* device instance $663 m0 *1 4772.16,1985.2 P
M$663 \$18 \$I332192 \$1848 \$18 P L=1.5U W=50U AS=120P AD=119.375P PS=81.7U
+ PD=81.6U
* device instance $667 m0 *1 5174.65,1651.425 N
M$667 VSS \$I332193 \$2012 VSS N L=1.2U W=25U AS=59.6875P AD=59.6875P PS=50.35U
+ PD=50.35U
* device instance $671 m0 *1 5145.8,1654.2 N
M$671 VSS \$2098 \$I332193 VSS N L=1.2U W=30U AS=71.625P AD=71.625P PS=56.6U
+ PD=56.6U
* device instance $675 m0 *1 5146,1629.15 P
M$675 \$18 \$2098 \$I332193 \$18 P L=1.5U W=60U AS=144P AD=143.25P PS=94.2U
+ PD=94.1U
* device instance $679 m0 *1 5173.55,1630.4 P
M$679 \$18 \$I332193 \$2012 \$18 P L=1.5U W=50U AS=120P AD=119.375P PS=81.7U
+ PD=81.6U
* device instance $683 m0 *1 2249.63,4135.025 N
M$683 VSS \$I332194 \$9509 VSS N L=1.2U W=25U AS=59.6875P AD=59.6875P PS=50.35U
+ PD=50.35U
* device instance $687 m0 *1 2220.78,4137.8 N
M$687 VSS \$8668 \$I332194 VSS N L=1.2U W=30U AS=71.625P AD=71.625P PS=56.6U
+ PD=56.6U
* device instance $691 m0 *1 2220.98,4112.75 P
M$691 \$18 \$8668 \$I332194 \$18 P L=1.5U W=60U AS=144P AD=143.25P PS=94.2U
+ PD=94.1U
* device instance $695 m0 *1 2248.53,4114 P
M$695 \$18 \$I332194 \$9509 \$18 P L=1.5U W=50U AS=120P AD=119.375P PS=81.7U
+ PD=81.6U
* device instance $699 m0 *1 779.66,3602.825 N
M$699 VSS \$I332195 \$6332 VSS N L=1.2U W=25U AS=59.6875P AD=59.6875P PS=50.35U
+ PD=50.35U
* device instance $703 m0 *1 750.81,3605.6 N
M$703 VSS \$7254 \$I332195 VSS N L=1.2U W=30U AS=71.625P AD=71.625P PS=56.6U
+ PD=56.6U
* device instance $707 m0 *1 751.01,3580.55 P
M$707 \$18 \$7254 \$I332195 \$18 P L=1.5U W=60U AS=144P AD=143.25P PS=94.2U
+ PD=94.1U
* device instance $711 m0 *1 778.56,3581.8 P
M$711 \$18 \$I332195 \$6332 \$18 P L=1.5U W=50U AS=120P AD=119.375P PS=81.7U
+ PD=81.6U
* device instance $715 m0 *1 882.35,3602.825 N
M$715 VSS \$I332196 \$7136 VSS N L=1.2U W=25U AS=59.6875P AD=59.6875P PS=50.35U
+ PD=50.35U
* device instance $719 m0 *1 853.5,3605.6 N
M$719 VSS \$6793 \$I332196 VSS N L=1.2U W=30U AS=71.625P AD=71.625P PS=56.6U
+ PD=56.6U
* device instance $723 m0 *1 853.7,3580.55 P
M$723 \$18 \$6793 \$I332196 \$18 P L=1.5U W=60U AS=144P AD=143.25P PS=94.2U
+ PD=94.1U
* device instance $727 m0 *1 881.25,3581.8 P
M$727 \$18 \$I332196 \$7136 \$18 P L=1.5U W=50U AS=120P AD=119.375P PS=81.7U
+ PD=81.6U
* device instance $731 m0 *1 2582.12,3602.825 N
M$731 VSS \$I332197 \$6650 VSS N L=1.2U W=25U AS=59.6875P AD=59.6875P PS=50.35U
+ PD=50.35U
* device instance $735 m0 *1 2553.27,3605.6 N
M$735 VSS \$7220 \$I332197 VSS N L=1.2U W=30U AS=71.625P AD=71.625P PS=56.6U
+ PD=56.6U
* device instance $739 m0 *1 2553.47,3580.55 P
M$739 \$18 \$7220 \$I332197 \$18 P L=1.5U W=60U AS=144P AD=143.25P PS=94.2U
+ PD=94.1U
* device instance $743 m0 *1 2581.02,3581.8 P
M$743 \$18 \$I332197 \$6650 \$18 P L=1.5U W=50U AS=120P AD=119.375P PS=81.7U
+ PD=81.6U
* device instance $747 m0 *1 2187.23,2361.025 N
M$747 VSS \$I332198 \$3431 VSS N L=1.2U W=25U AS=59.6875P AD=59.6875P PS=50.35U
+ PD=50.35U
* device instance $751 m0 *1 2158.38,2363.8 N
M$751 VSS \$3071 \$I332198 VSS N L=1.2U W=30U AS=71.625P AD=71.625P PS=56.6U
+ PD=56.6U
* device instance $755 m0 *1 2158.58,2338.75 P
M$755 \$18 \$3071 \$I332198 \$18 P L=1.5U W=60U AS=144P AD=143.25P PS=94.2U
+ PD=94.1U
* device instance $759 m0 *1 2186.13,2340 P
M$759 \$18 \$I332198 \$3431 \$18 P L=1.5U W=50U AS=120P AD=119.375P PS=81.7U
+ PD=81.6U
* device instance $763 m0 *1 2383.9,2361.025 N
M$763 VSS \$I332199 \$3435 VSS N L=1.2U W=25U AS=59.6875P AD=59.6875P PS=50.35U
+ PD=50.35U
* device instance $767 m0 *1 2355.05,2363.8 N
M$767 VSS \$3431 \$I332199 VSS N L=1.2U W=30U AS=71.625P AD=71.625P PS=56.6U
+ PD=56.6U
* device instance $771 m0 *1 2355.25,2338.75 P
M$771 \$18 \$3431 \$I332199 \$18 P L=1.5U W=60U AS=144P AD=143.25P PS=94.2U
+ PD=94.1U
* device instance $775 m0 *1 2382.8,2340 P
M$775 \$18 \$I332199 \$3435 \$18 P L=1.5U W=50U AS=120P AD=119.375P PS=81.7U
+ PD=81.6U
* device instance $779 m0 *1 526.82,3425.425 N
M$779 VSS \$I332200 \$6515 VSS N L=1.2U W=25U AS=59.6875P AD=59.6875P PS=50.35U
+ PD=50.35U
* device instance $783 m0 *1 497.97,3428.2 N
M$783 VSS \$5408 \$I332200 VSS N L=1.2U W=30U AS=71.625P AD=71.625P PS=56.6U
+ PD=56.6U
* device instance $787 m0 *1 498.17,3403.15 P
M$787 \$18 \$5408 \$I332200 \$18 P L=1.5U W=60U AS=144P AD=143.25P PS=94.2U
+ PD=94.1U
* device instance $791 m0 *1 525.72,3404.4 P
M$791 \$18 \$I332200 \$6515 \$18 P L=1.5U W=50U AS=120P AD=119.375P PS=81.7U
+ PD=81.6U
* device instance $795 m0 *1 217.84,3780.225 N
M$795 VSS \$I332201 \$7587 VSS N L=1.2U W=25U AS=59.6875P AD=59.6875P PS=50.35U
+ PD=50.35U
* device instance $799 m0 *1 188.99,3783 N
M$799 VSS \$7041 \$I332201 VSS N L=1.2U W=30U AS=71.625P AD=71.625P PS=56.6U
+ PD=56.6U
* device instance $803 m0 *1 189.19,3757.95 P
M$803 \$18 \$7041 \$I332201 \$18 P L=1.5U W=60U AS=144P AD=143.25P PS=94.2U
+ PD=94.1U
* device instance $807 m0 *1 216.74,3759.2 P
M$807 \$18 \$I332201 \$7587 \$18 P L=1.5U W=50U AS=120P AD=119.375P PS=81.7U
+ PD=81.6U
* device instance $811 m0 *1 453.14,3780.225 N
M$811 VSS \$I332202 \$7694 VSS N L=1.2U W=25U AS=59.6875P AD=59.6875P PS=50.35U
+ PD=50.35U
* device instance $815 m0 *1 424.29,3783 N
M$815 VSS \$7770 \$I332202 VSS N L=1.2U W=30U AS=71.625P AD=71.625P PS=56.6U
+ PD=56.6U
* device instance $819 m0 *1 424.49,3757.95 P
M$819 \$18 \$7770 \$I332202 \$18 P L=1.5U W=60U AS=144P AD=143.25P PS=94.2U
+ PD=94.1U
* device instance $823 m0 *1 452.04,3759.2 P
M$823 \$18 \$I332202 \$7694 \$18 P L=1.5U W=50U AS=120P AD=119.375P PS=81.7U
+ PD=81.6U
* device instance $827 m0 *1 923.71,3780.225 N
M$827 VSS \$I332203 \$7517 VSS N L=1.2U W=25U AS=59.6875P AD=59.6875P PS=50.35U
+ PD=50.35U
* device instance $831 m0 *1 894.86,3783 N
M$831 VSS \$7405 \$I332203 VSS N L=1.2U W=30U AS=71.625P AD=71.625P PS=56.6U
+ PD=56.6U
* device instance $835 m0 *1 895.06,3757.95 P
M$835 \$18 \$7405 \$I332203 \$18 P L=1.5U W=60U AS=144P AD=143.25P PS=94.2U
+ PD=94.1U
* device instance $839 m0 *1 922.61,3759.2 P
M$839 \$18 \$I332203 \$7517 \$18 P L=1.5U W=50U AS=120P AD=119.375P PS=81.7U
+ PD=81.6U
* device instance $843 m0 *1 1581.7,3070.625 N
M$843 VSS \$I332204 \$5011 VSS N L=1.2U W=25U AS=59.6875P AD=59.6875P PS=50.35U
+ PD=50.35U
* device instance $847 m0 *1 1552.85,3073.4 N
M$847 VSS \$5255 \$I332204 VSS N L=1.2U W=30U AS=71.625P AD=71.625P PS=56.6U
+ PD=56.6U
* device instance $851 m0 *1 1553.05,3048.35 P
M$851 \$18 \$5255 \$I332204 \$18 P L=1.5U W=60U AS=144P AD=143.25P PS=94.2U
+ PD=94.1U
* device instance $855 m0 *1 1580.6,3049.6 P
M$855 \$18 \$I332204 \$5011 \$18 P L=1.5U W=50U AS=120P AD=119.375P PS=81.7U
+ PD=81.6U
* device instance $859 r180 *1 1767.81,2538.425 N
M$859 VSS \$I332205 \$3904 VSS N L=1.2U W=25U AS=59.6875P AD=59.6875P PS=50.35U
+ PD=50.35U
* device instance $863 r180 *1 1796.66,2541.2 N
M$863 VSS \$3647 \$I332205 VSS N L=1.2U W=30U AS=71.625P AD=71.625P PS=56.6U
+ PD=56.6U
* device instance $867 r180 *1 1796.46,2516.15 P
M$867 \$18 \$3647 \$I332205 \$18 P L=1.5U W=60U AS=144P AD=143.25P PS=94.2U
+ PD=94.1U
* device instance $871 r180 *1 1768.91,2517.4 P
M$871 \$18 \$I332205 \$3904 \$18 P L=1.5U W=50U AS=120P AD=119.375P PS=81.7U
+ PD=81.6U
* device instance $875 m0 *1 3963.48,1296.625 N
M$875 VSS \$I332206 \$1596 VSS N L=1.2U W=25U AS=59.6875P AD=59.6875P PS=50.35U
+ PD=50.35U
* device instance $879 m0 *1 3934.63,1299.4 N
M$879 VSS \$1558 \$I332206 VSS N L=1.2U W=30U AS=71.625P AD=71.625P PS=56.6U
+ PD=56.6U
* device instance $883 m0 *1 3934.83,1274.35 P
M$883 \$18 \$1558 \$I332206 \$18 P L=1.5U W=60U AS=144P AD=143.25P PS=94.2U
+ PD=94.1U
* device instance $887 m0 *1 3962.38,1275.6 P
M$887 \$18 \$I332206 \$1596 \$18 P L=1.5U W=50U AS=120P AD=119.375P PS=81.7U
+ PD=81.6U
* device instance $891 r180 *1 4054.15,1296.625 N
M$891 VSS \$I332207 \$1560 VSS N L=1.2U W=25U AS=59.6875P AD=59.6875P PS=50.35U
+ PD=50.35U
* device instance $895 r180 *1 4083,1299.4 N
M$895 VSS \$1437 \$I332207 VSS N L=1.2U W=30U AS=71.625P AD=71.625P PS=56.6U
+ PD=56.6U
* device instance $899 r180 *1 4082.8,1274.35 P
M$899 \$18 \$1437 \$I332207 \$18 P L=1.5U W=60U AS=144P AD=143.25P PS=94.2U
+ PD=94.1U
* device instance $903 r180 *1 4055.25,1275.6 P
M$903 \$18 \$I332207 \$1560 \$18 P L=1.5U W=50U AS=120P AD=119.375P PS=81.7U
+ PD=81.6U
* device instance $907 m0 *1 4910.21,409.625 N
M$907 VSS \$I332208 \$529 VSS N L=1.2U W=25U AS=59.6875P AD=59.6875P PS=50.35U
+ PD=50.35U
* device instance $911 m0 *1 4881.36,412.4 N
M$911 VSS \$422 \$I332208 VSS N L=1.2U W=30U AS=71.625P AD=71.625P PS=56.6U
+ PD=56.6U
* device instance $915 m0 *1 4881.56,387.35 P
M$915 \$18 \$422 \$I332208 \$18 P L=1.5U W=60U AS=144P AD=143.25P PS=94.2U
+ PD=94.1U
* device instance $919 m0 *1 4909.11,388.6 P
M$919 \$18 \$I332208 \$529 \$18 P L=1.5U W=50U AS=120P AD=119.375P PS=81.7U
+ PD=81.6U
* device instance $923 r180 *1 4155.4,764.425 N
M$923 VSS \$I332209 \$843 VSS N L=1.2U W=25U AS=59.6875P AD=59.6875P PS=50.35U
+ PD=50.35U
* device instance $927 r180 *1 4184.25,767.2 N
M$927 VSS \$725 \$I332209 VSS N L=1.2U W=30U AS=71.625P AD=71.625P PS=56.6U
+ PD=56.6U
* device instance $931 r180 *1 4184.05,742.15 P
M$931 \$18 \$725 \$I332209 \$18 P L=1.5U W=60U AS=144P AD=143.25P PS=94.2U
+ PD=94.1U
* device instance $935 r180 *1 4156.5,743.4 P
M$935 \$18 \$I332209 \$843 \$18 P L=1.5U W=50U AS=120P AD=119.375P PS=81.7U
+ PD=81.6U
* device instance $939 m0 *1 4586.63,1474.025 N
M$939 VSS \$I332210 \$1800 VSS N L=1.2U W=25U AS=59.6875P AD=59.6875P PS=50.35U
+ PD=50.35U
* device instance $943 m0 *1 4557.78,1476.8 N
M$943 VSS \$1837 \$I332210 VSS N L=1.2U W=30U AS=71.625P AD=71.625P PS=56.6U
+ PD=56.6U
* device instance $947 m0 *1 4557.98,1451.75 P
M$947 \$18 \$1837 \$I332210 \$18 P L=1.5U W=60U AS=144P AD=143.25P PS=94.2U
+ PD=94.1U
* device instance $951 m0 *1 4585.53,1453 P
M$951 \$18 \$I332210 \$1800 \$18 P L=1.5U W=50U AS=120P AD=119.375P PS=81.7U
+ PD=81.6U
* device instance $955 m0 *1 4766.83,1474.025 N
M$955 VSS \$I332211 \$1799 VSS N L=1.2U W=25U AS=59.6875P AD=59.6875P PS=50.35U
+ PD=50.35U
* device instance $959 m0 *1 4737.98,1476.8 N
M$959 VSS \$1848 \$I332211 VSS N L=1.2U W=30U AS=71.625P AD=71.625P PS=56.6U
+ PD=56.6U
* device instance $963 m0 *1 4738.18,1451.75 P
M$963 \$18 \$1848 \$I332211 \$18 P L=1.5U W=60U AS=144P AD=143.25P PS=94.2U
+ PD=94.1U
* device instance $967 m0 *1 4765.73,1453 P
M$967 \$18 \$I332211 \$1799 \$18 P L=1.5U W=50U AS=120P AD=119.375P PS=81.7U
+ PD=81.6U
* device instance $971 m0 *1 5316.79,1474.025 N
M$971 VSS \$I332212 \$1067 VSS N L=1.2U W=25U AS=59.6875P AD=59.6875P PS=50.35U
+ PD=50.35U
* device instance $975 m0 *1 5287.94,1476.8 N
M$975 VSS \$1800 \$I332212 VSS N L=1.2U W=30U AS=71.625P AD=71.625P PS=56.6U
+ PD=56.6U
* device instance $979 m0 *1 5288.14,1451.75 P
M$979 \$18 \$1800 \$I332212 \$18 P L=1.5U W=60U AS=144P AD=143.25P PS=94.2U
+ PD=94.1U
* device instance $983 m0 *1 5315.69,1453 P
M$983 \$18 \$I332212 \$1067 \$18 P L=1.5U W=50U AS=120P AD=119.375P PS=81.7U
+ PD=81.6U
* device instance $987 m0 *1 4825.47,587.025 N
M$987 VSS \$I332213 \$686 VSS N L=1.2U W=25U AS=59.6875P AD=59.6875P PS=50.35U
+ PD=50.35U
* device instance $991 m0 *1 4796.62,589.8 N
M$991 VSS \$685 \$I332213 VSS N L=1.2U W=30U AS=71.625P AD=71.625P PS=56.6U
+ PD=56.6U
* device instance $995 m0 *1 4796.82,564.75 P
M$995 \$18 \$685 \$I332213 \$18 P L=1.5U W=60U AS=144P AD=143.25P PS=94.2U
+ PD=94.1U
* device instance $999 m0 *1 4824.37,566 P
M$999 \$18 \$I332213 \$686 \$18 P L=1.5U W=50U AS=120P AD=119.375P PS=81.7U
+ PD=81.6U
* device instance $1003 m90 *1 947.34,5621.975 N
M$1003 VSS \$I332214 \$18053 VSS N L=1.2U W=25U AS=59.6875P AD=59.6875P
+ PS=50.35U PD=50.35U
* device instance $1007 m90 *1 976.19,5619.2 N
M$1007 VSS \$17129 \$I332214 VSS N L=1.2U W=30U AS=71.625P AD=71.625P PS=56.6U
+ PD=56.6U
* device instance $1011 m90 *1 975.99,5644.25 P
M$1011 \$18 \$17129 \$I332214 \$18 P L=1.5U W=60U AS=144P AD=143.25P PS=94.2U
+ PD=94.1U
* device instance $1015 m90 *1 948.44,5643 P
M$1015 \$18 \$I332214 \$18053 \$18 P L=1.5U W=50U AS=120P AD=119.375P PS=81.7U
+ PD=81.6U
* device instance $1019 m90 *1 1045.16,5621.975 N
M$1019 VSS \$I332215 \$18055 VSS N L=1.2U W=25U AS=59.6875P AD=59.6875P
+ PS=50.35U PD=50.35U
* device instance $1023 m90 *1 1074.01,5619.2 N
M$1023 VSS \$18053 \$I332215 VSS N L=1.2U W=30U AS=71.625P AD=71.625P PS=56.6U
+ PD=56.6U
* device instance $1027 m90 *1 1073.81,5644.25 P
M$1027 \$18 \$18053 \$I332215 \$18 P L=1.5U W=60U AS=144P AD=143.25P PS=94.2U
+ PD=94.1U
* device instance $1031 m90 *1 1046.26,5643 P
M$1031 \$18 \$I332215 \$18055 \$18 P L=1.5U W=50U AS=120P AD=119.375P PS=81.7U
+ PD=81.6U
* device instance $1035 r0 *1 1173.22,5621.975 N
M$1035 VSS \$I332216 \$17808 VSS N L=1.2U W=25U AS=59.6875P AD=59.6875P
+ PS=50.35U PD=50.35U
* device instance $1039 r0 *1 1144.37,5619.2 N
M$1039 VSS \$18060 \$I332216 VSS N L=1.2U W=30U AS=71.625P AD=71.625P PS=56.6U
+ PD=56.6U
* device instance $1043 r0 *1 1144.57,5644.25 P
M$1043 \$18 \$18060 \$I332216 \$18 P L=1.5U W=60U AS=144P AD=143.25P PS=94.2U
+ PD=94.1U
* device instance $1047 r0 *1 1172.12,5643 P
M$1047 \$18 \$I332216 \$17808 \$18 P L=1.5U W=50U AS=120P AD=119.375P PS=81.7U
+ PD=81.6U
* device instance $1051 m90 *1 107.48,5976.775 N
M$1051 VSS \$I332217 \$3877 VSS N L=1.2U W=25U AS=59.6875P AD=59.6875P
+ PS=50.35U PD=50.35U
* device instance $1055 m90 *1 136.33,5974 N
M$1055 VSS \$19134 \$I332217 VSS N L=1.2U W=30U AS=71.625P AD=71.625P PS=56.6U
+ PD=56.6U
* device instance $1059 m90 *1 136.13,5999.05 P
M$1059 \$18 \$19134 \$I332217 \$18 P L=1.5U W=60U AS=144P AD=143.25P PS=94.2U
+ PD=94.1U
* device instance $1063 m90 *1 108.58,5997.8 P
M$1063 \$18 \$I332217 \$3877 \$18 P L=1.5U W=50U AS=120P AD=119.375P PS=81.7U
+ PD=81.6U
* device instance $1067 m90 *1 304.3,5799.375 N
M$1067 VSS \$I332218 \$17212 VSS N L=1.2U W=25U AS=59.6875P AD=59.6875P
+ PS=50.35U PD=50.35U
* device instance $1071 m90 *1 333.15,5796.6 N
M$1071 VSS \$18039 \$I332218 VSS N L=1.2U W=30U AS=71.625P AD=71.625P PS=56.6U
+ PD=56.6U
* device instance $1075 m90 *1 332.95,5821.65 P
M$1075 \$18 \$18039 \$I332218 \$18 P L=1.5U W=60U AS=144P AD=143.25P PS=94.2U
+ PD=94.1U
* device instance $1079 m90 *1 305.4,5820.4 P
M$1079 \$18 \$I332218 \$17212 \$18 P L=1.5U W=50U AS=120P AD=119.375P PS=81.7U
+ PD=81.6U
* device instance $1083 m90 *1 424.55,5799.375 N
M$1083 VSS \$I332219 \$18915 VSS N L=1.2U W=25U AS=59.6875P AD=59.6875P
+ PS=50.35U PD=50.35U
* device instance $1087 m90 *1 453.4,5796.6 N
M$1087 VSS \$18368 \$I332219 VSS N L=1.2U W=30U AS=71.625P AD=71.625P PS=56.6U
+ PD=56.6U
* device instance $1091 m90 *1 453.2,5821.65 P
M$1091 \$18 \$18368 \$I332219 \$18 P L=1.5U W=60U AS=144P AD=143.25P PS=94.2U
+ PD=94.1U
* device instance $1095 m90 *1 425.65,5820.4 P
M$1095 \$18 \$I332219 \$18915 \$18 P L=1.5U W=50U AS=120P AD=119.375P PS=81.7U
+ PD=81.6U
* device instance $1099 r0 *1 2139.32,5799.375 N
M$1099 VSS \$I332220 \$17828 VSS N L=1.2U W=25U AS=59.6875P AD=59.6875P
+ PS=50.35U PD=50.35U
* device instance $1103 r0 *1 2110.47,5796.6 N
M$1103 VSS \$18627 \$I332220 VSS N L=1.2U W=30U AS=71.625P AD=71.625P PS=56.6U
+ PD=56.6U
* device instance $1107 r0 *1 2110.67,5821.65 P
M$1107 \$18 \$18627 \$I332220 \$18 P L=1.5U W=60U AS=144P AD=143.25P PS=94.2U
+ PD=94.1U
* device instance $1111 r0 *1 2138.22,5820.4 P
M$1111 \$18 \$I332220 \$17828 \$18 P L=1.5U W=50U AS=120P AD=119.375P PS=81.7U
+ PD=81.6U
* device instance $1115 r0 *1 956.05,4912.375 N
M$1115 VSS \$I332221 \$14393 VSS N L=1.2U W=25U AS=59.6875P AD=59.6875P
+ PS=50.35U PD=50.35U
* device instance $1119 r0 *1 927.2,4909.6 N
M$1119 VSS \$13082 \$I332221 VSS N L=1.2U W=30U AS=71.625P AD=71.625P PS=56.6U
+ PD=56.6U
* device instance $1123 r0 *1 927.4,4934.65 P
M$1123 \$18 \$13082 \$I332221 \$18 P L=1.5U W=60U AS=144P AD=143.25P PS=94.2U
+ PD=94.1U
* device instance $1127 r0 *1 954.95,4933.4 P
M$1127 \$18 \$I332221 \$14393 \$18 P L=1.5U W=50U AS=120P AD=119.375P PS=81.7U
+ PD=81.6U
* device instance $1131 r0 *1 1909.75,4912.375 N
M$1131 VSS \$I332222 \$14618 VSS N L=1.2U W=25U AS=59.6875P AD=59.6875P
+ PS=50.35U PD=50.35U
* device instance $1135 r0 *1 1880.9,4909.6 N
M$1135 VSS \$13575 \$I332222 VSS N L=1.2U W=30U AS=71.625P AD=71.625P PS=56.6U
+ PD=56.6U
* device instance $1139 r0 *1 1881.1,4934.65 P
M$1139 \$18 \$13575 \$I332222 \$18 P L=1.5U W=60U AS=144P AD=143.25P PS=94.2U
+ PD=94.1U
* device instance $1143 r0 *1 1908.65,4933.4 P
M$1143 \$18 \$I332222 \$14618 \$18 P L=1.5U W=50U AS=120P AD=119.375P PS=81.7U
+ PD=81.6U
* device instance $1147 m90 *1 2034.82,4912.375 N
M$1147 VSS \$I332223 \$14614 VSS N L=1.2U W=25U AS=59.6875P AD=59.6875P
+ PS=50.35U PD=50.35U
* device instance $1151 m90 *1 2063.67,4909.6 N
M$1151 VSS \$14618 \$I332223 VSS N L=1.2U W=30U AS=71.625P AD=71.625P PS=56.6U
+ PD=56.6U
* device instance $1155 m90 *1 2063.47,4934.65 P
M$1155 \$18 \$14618 \$I332223 \$18 P L=1.5U W=60U AS=144P AD=143.25P PS=94.2U
+ PD=94.1U
* device instance $1159 m90 *1 2035.92,4933.4 P
M$1159 \$18 \$I332223 \$14614 \$18 P L=1.5U W=50U AS=120P AD=119.375P PS=81.7U
+ PD=81.6U
* device instance $1163 m90 *1 1423.41,6331.575 N
M$1163 VSS \$I332224 \$19646 VSS N L=1.2U W=25U AS=59.6875P AD=59.6875P
+ PS=50.35U PD=50.35U
* device instance $1167 m90 *1 1452.26,6328.8 N
M$1167 VSS \$19645 \$I332224 VSS N L=1.2U W=30U AS=71.625P AD=71.625P PS=56.6U
+ PD=56.6U
* device instance $1171 m90 *1 1452.06,6353.85 P
M$1171 \$18 \$19645 \$I332224 \$18 P L=1.5U W=60U AS=144P AD=143.25P PS=94.2U
+ PD=94.1U
* device instance $1175 m90 *1 1424.51,6352.6 P
M$1175 \$18 \$I332224 \$19646 \$18 P L=1.5U W=50U AS=120P AD=119.375P PS=81.7U
+ PD=81.6U
* device instance $1179 m90 *1 1478.62,6331.575 N
M$1179 VSS \$I332225 \$19790 VSS N L=1.2U W=25U AS=59.6875P AD=59.6875P
+ PS=50.35U PD=50.35U
* device instance $1183 m90 *1 1507.47,6328.8 N
M$1183 VSS \$19764 \$I332225 VSS N L=1.2U W=30U AS=71.625P AD=71.625P PS=56.6U
+ PD=56.6U
* device instance $1187 m90 *1 1507.27,6353.85 P
M$1187 \$18 \$19764 \$I332225 \$18 P L=1.5U W=60U AS=144P AD=143.25P PS=94.2U
+ PD=94.1U
* device instance $1191 m90 *1 1479.72,6352.6 P
M$1191 \$18 \$I332225 \$19790 \$18 P L=1.5U W=50U AS=120P AD=119.375P PS=81.7U
+ PD=81.6U
* device instance $1195 r0 *1 1075.61,6154.175 N
M$1195 VSS \$I332226 \$19049 VSS N L=1.2U W=25U AS=59.6875P AD=59.6875P
+ PS=50.35U PD=50.35U
* device instance $1199 r0 *1 1046.76,6151.4 N
M$1199 VSS \$19551 \$I332226 VSS N L=1.2U W=30U AS=71.625P AD=71.625P PS=56.6U
+ PD=56.6U
* device instance $1203 r0 *1 1046.96,6176.45 P
M$1203 \$18 \$19551 \$I332226 \$18 P L=1.5U W=60U AS=144P AD=143.25P PS=94.2U
+ PD=94.1U
* device instance $1207 r0 *1 1074.51,6175.2 P
M$1207 \$18 \$I332226 \$19049 \$18 P L=1.5U W=50U AS=120P AD=119.375P PS=81.7U
+ PD=81.6U
* device instance $1211 r0 *1 1389.94,6154.175 N
M$1211 VSS \$I332227 \$19689 VSS N L=1.2U W=25U AS=59.6875P AD=59.6875P
+ PS=50.35U PD=50.35U
* device instance $1215 r0 *1 1361.09,6151.4 N
M$1215 VSS \$19597 \$I332227 VSS N L=1.2U W=30U AS=71.625P AD=71.625P PS=56.6U
+ PD=56.6U
* device instance $1219 r0 *1 1361.29,6176.45 P
M$1219 \$18 \$19597 \$I332227 \$18 P L=1.5U W=60U AS=144P AD=143.25P PS=94.2U
+ PD=94.1U
* device instance $1223 r0 *1 1388.84,6175.2 P
M$1223 \$18 \$I332227 \$19689 \$18 P L=1.5U W=50U AS=120P AD=119.375P PS=81.7U
+ PD=81.6U
* device instance $1227 m90 *1 1452.14,6154.175 N
M$1227 VSS \$I332228 \$18953 VSS N L=1.2U W=25U AS=59.6875P AD=59.6875P
+ PS=50.35U PD=50.35U
* device instance $1231 m90 *1 1480.99,6151.4 N
M$1231 VSS \$19394 \$I332228 VSS N L=1.2U W=30U AS=71.625P AD=71.625P PS=56.6U
+ PD=56.6U
* device instance $1235 m90 *1 1480.79,6176.45 P
M$1235 \$18 \$19394 \$I332228 \$18 P L=1.5U W=60U AS=144P AD=143.25P PS=94.2U
+ PD=94.1U
* device instance $1239 m90 *1 1453.24,6175.2 P
M$1239 \$18 \$I332228 \$18953 \$18 P L=1.5U W=50U AS=120P AD=119.375P PS=81.7U
+ PD=81.6U
* device instance $1243 r0 *1 1678.39,6154.175 N
M$1243 VSS \$I332229 \$19601 VSS N L=1.2U W=25U AS=59.6875P AD=59.6875P
+ PS=50.35U PD=50.35U
* device instance $1247 r0 *1 1649.54,6151.4 N
M$1247 VSS \$19196 \$I332229 VSS N L=1.2U W=30U AS=71.625P AD=71.625P PS=56.6U
+ PD=56.6U
* device instance $1251 r0 *1 1649.74,6176.45 P
M$1251 \$18 \$19196 \$I332229 \$18 P L=1.5U W=60U AS=144P AD=143.25P PS=94.2U
+ PD=94.1U
* device instance $1255 r0 *1 1677.29,6175.2 P
M$1255 \$18 \$I332229 \$19601 \$18 P L=1.5U W=50U AS=120P AD=119.375P PS=81.7U
+ PD=81.6U
* device instance $1259 r0 *1 1173.04,5444.575 N
M$1259 VSS \$I332230 \$17129 VSS N L=1.2U W=25U AS=59.6875P AD=59.6875P
+ PS=50.35U PD=50.35U
* device instance $1263 r0 *1 1144.19,5441.8 N
M$1263 VSS \$17014 \$I332230 VSS N L=1.2U W=30U AS=71.625P AD=71.625P PS=56.6U
+ PD=56.6U
* device instance $1267 r0 *1 1144.39,5466.85 P
M$1267 \$18 \$17014 \$I332230 \$18 P L=1.5U W=60U AS=144P AD=143.25P PS=94.2U
+ PD=94.1U
* device instance $1271 r0 *1 1171.94,5465.6 P
M$1271 \$18 \$I332230 \$17129 \$18 P L=1.5U W=50U AS=120P AD=119.375P PS=81.7U
+ PD=81.6U
* device instance $1275 r0 *1 347.55,5267.175 N
M$1275 VSS \$I332231 \$16517 VSS N L=1.2U W=25U AS=59.6875P AD=59.6875P
+ PS=50.35U PD=50.35U
* device instance $1279 r0 *1 318.7,5264.4 N
M$1279 VSS \$16077 \$I332231 VSS N L=1.2U W=30U AS=71.625P AD=71.625P PS=56.6U
+ PD=56.6U
* device instance $1283 r0 *1 318.9,5289.45 P
M$1283 \$18 \$16077 \$I332231 \$18 P L=1.5U W=60U AS=144P AD=143.25P PS=94.2U
+ PD=94.1U
* device instance $1287 r0 *1 346.45,5288.2 P
M$1287 \$18 \$I332231 \$16517 \$18 P L=1.5U W=50U AS=120P AD=119.375P PS=81.7U
+ PD=81.6U
* device instance $1291 r0 *1 527.84,5267.175 N
M$1291 VSS \$I332232 \$16527 VSS N L=1.2U W=25U AS=59.6875P AD=59.6875P
+ PS=50.35U PD=50.35U
* device instance $1295 r0 *1 498.99,5264.4 N
M$1295 VSS \$16465 \$I332232 VSS N L=1.2U W=30U AS=71.625P AD=71.625P PS=56.6U
+ PD=56.6U
* device instance $1299 r0 *1 499.19,5289.45 P
M$1299 \$18 \$16465 \$I332232 \$18 P L=1.5U W=60U AS=144P AD=143.25P PS=94.2U
+ PD=94.1U
* device instance $1303 r0 *1 526.74,5288.2 P
M$1303 \$18 \$I332232 \$16527 \$18 P L=1.5U W=50U AS=120P AD=119.375P PS=81.7U
+ PD=81.6U
* device instance $1307 r0 *1 2029.28,5267.175 N
M$1307 VSS \$I332233 \$11172 VSS N L=1.2U W=25U AS=59.6875P AD=59.6875P
+ PS=50.35U PD=50.35U
* device instance $1311 r0 *1 2000.43,5264.4 N
M$1311 VSS \$16592 \$I332233 VSS N L=1.2U W=30U AS=71.625P AD=71.625P PS=56.6U
+ PD=56.6U
* device instance $1315 r0 *1 2000.63,5289.45 P
M$1315 \$18 \$16592 \$I332233 \$18 P L=1.5U W=60U AS=144P AD=143.25P PS=94.2U
+ PD=94.1U
* device instance $1319 r0 *1 2028.18,5288.2 P
M$1319 \$18 \$I332233 \$11172 \$18 P L=1.5U W=50U AS=120P AD=119.375P PS=81.7U
+ PD=81.6U
* device instance $1323 r0 *1 2416.03,5267.175 N
M$1323 VSS \$I332234 \$16612 VSS N L=1.2U W=25U AS=59.6875P AD=59.6875P
+ PS=50.35U PD=50.35U
* device instance $1327 r0 *1 2387.18,5264.4 N
M$1327 VSS \$16164 \$I332234 VSS N L=1.2U W=30U AS=71.625P AD=71.625P PS=56.6U
+ PD=56.6U
* device instance $1331 r0 *1 2387.38,5289.45 P
M$1331 \$18 \$16164 \$I332234 \$18 P L=1.5U W=60U AS=144P AD=143.25P PS=94.2U
+ PD=94.1U
* device instance $1335 r0 *1 2414.93,5288.2 P
M$1335 \$18 \$I332234 \$16612 \$18 P L=1.5U W=50U AS=120P AD=119.375P PS=81.7U
+ PD=81.6U
* device instance $1339 r0 *1 186.41,3847.975 N
M$1339 VSS \$I332235 \$7472 VSS N L=1.2U W=25U AS=59.6875P AD=59.6875P
+ PS=50.35U PD=50.35U
* device instance $1343 r0 *1 157.56,3845.2 N
M$1343 VSS \$8115 \$I332235 VSS N L=1.2U W=30U AS=71.625P AD=71.625P PS=56.6U
+ PD=56.6U
* device instance $1347 r0 *1 157.76,3870.25 P
M$1347 \$18 \$8115 \$I332235 \$18 P L=1.5U W=60U AS=144P AD=143.25P PS=94.2U
+ PD=94.1U
* device instance $1351 r0 *1 185.31,3869 P
M$1351 \$18 \$I332235 \$7472 \$18 P L=1.5U W=50U AS=120P AD=119.375P PS=81.7U
+ PD=81.6U
* device instance $1355 r0 *1 1342.98,3138.375 N
M$1355 VSS \$I332236 \$5753 VSS N L=1.2U W=25U AS=59.6875P AD=59.6875P
+ PS=50.35U PD=50.35U
* device instance $1359 r0 *1 1314.13,3135.6 N
M$1359 VSS \$5751 \$I332236 VSS N L=1.2U W=30U AS=71.625P AD=71.625P PS=56.6U
+ PD=56.6U
* device instance $1363 r0 *1 1314.33,3160.65 P
M$1363 \$18 \$5751 \$I332236 \$18 P L=1.5U W=60U AS=144P AD=143.25P PS=94.2U
+ PD=94.1U
* device instance $1367 r0 *1 1341.88,3159.4 P
M$1367 \$18 \$I332236 \$5753 \$18 P L=1.5U W=50U AS=120P AD=119.375P PS=81.7U
+ PD=81.6U
* device instance $1371 r0 *1 1737.94,3138.375 N
M$1371 VSS \$I332237 \$5770 VSS N L=1.2U W=25U AS=59.6875P AD=59.6875P
+ PS=50.35U PD=50.35U
* device instance $1375 r0 *1 1709.09,3135.6 N
M$1375 VSS \$5442 \$I332237 VSS N L=1.2U W=30U AS=71.625P AD=71.625P PS=56.6U
+ PD=56.6U
* device instance $1379 r0 *1 1709.29,3160.65 P
M$1379 \$18 \$5442 \$I332237 \$18 P L=1.5U W=60U AS=144P AD=143.25P PS=94.2U
+ PD=94.1U
* device instance $1383 r0 *1 1736.84,3159.4 P
M$1383 \$18 \$I332237 \$5770 \$18 P L=1.5U W=50U AS=120P AD=119.375P PS=81.7U
+ PD=81.6U
* device instance $1387 m90 *1 4462.11,3138.375 N
M$1387 VSS \$I332238 \$4169 VSS N L=1.2U W=25U AS=59.6875P AD=59.6875P
+ PS=50.35U PD=50.35U
* device instance $1391 m90 *1 4490.96,3135.6 N
M$1391 VSS \$5794 \$I332238 VSS N L=1.2U W=30U AS=71.625P AD=71.625P PS=56.6U
+ PD=56.6U
* device instance $1395 m90 *1 4490.76,3160.65 P
M$1395 \$18 \$5794 \$I332238 \$18 P L=1.5U W=60U AS=144P AD=143.25P PS=94.2U
+ PD=94.1U
* device instance $1399 m90 *1 4463.21,3159.4 P
M$1399 \$18 \$I332238 \$4169 \$18 P L=1.5U W=50U AS=120P AD=119.375P PS=81.7U
+ PD=81.6U
* device instance $1403 r0 *1 675.32,2428.775 N
M$1403 VSS \$I332239 \$3622 VSS N L=1.2U W=25U AS=59.6875P AD=59.6875P
+ PS=50.35U PD=50.35U
* device instance $1407 r0 *1 646.47,2426 N
M$1407 VSS \$3396 \$I332239 VSS N L=1.2U W=30U AS=71.625P AD=71.625P PS=56.6U
+ PD=56.6U
* device instance $1411 r0 *1 646.67,2451.05 P
M$1411 \$18 \$3396 \$I332239 \$18 P L=1.5U W=60U AS=144P AD=143.25P PS=94.2U
+ PD=94.1U
* device instance $1415 r0 *1 674.22,2449.8 P
M$1415 \$18 \$I332239 \$3622 \$18 P L=1.5U W=50U AS=120P AD=119.375P PS=81.7U
+ PD=81.6U
* device instance $1419 r0 *1 4540.6,2251.375 N
M$1419 VSS \$I332240 \$3264 VSS N L=1.2U W=25U AS=59.6875P AD=59.6875P
+ PS=50.35U PD=50.35U
* device instance $1423 r0 *1 4511.75,2248.6 N
M$1423 VSS \$3263 \$I332240 VSS N L=1.2U W=30U AS=71.625P AD=71.625P PS=56.6U
+ PD=56.6U
* device instance $1427 r0 *1 4511.95,2273.65 P
M$1427 \$18 \$3263 \$I332240 \$18 P L=1.5U W=60U AS=144P AD=143.25P PS=94.2U
+ PD=94.1U
* device instance $1431 r0 *1 4539.5,2272.4 P
M$1431 \$18 \$I332240 \$3264 \$18 P L=1.5U W=50U AS=120P AD=119.375P PS=81.7U
+ PD=81.6U
* device instance $1435 r0 *1 689.43,2783.575 N
M$1435 VSS \$I332241 \$3407 VSS N L=1.2U W=25U AS=59.6875P AD=59.6875P
+ PS=50.35U PD=50.35U
* device instance $1439 r0 *1 660.58,2780.8 N
M$1439 VSS \$3856 \$I332241 VSS N L=1.2U W=30U AS=71.625P AD=71.625P PS=56.6U
+ PD=56.6U
* device instance $1443 r0 *1 660.78,2805.85 P
M$1443 \$18 \$3856 \$I332241 \$18 P L=1.5U W=60U AS=144P AD=143.25P PS=94.2U
+ PD=94.1U
* device instance $1447 r0 *1 688.33,2804.6 P
M$1447 \$18 \$I332241 \$3407 \$18 P L=1.5U W=50U AS=120P AD=119.375P PS=81.7U
+ PD=81.6U
* device instance $1451 r0 *1 2295.04,2783.575 N
M$1451 VSS \$I332242 \$4384 VSS N L=1.2U W=25U AS=59.6875P AD=59.6875P
+ PS=50.35U PD=50.35U
* device instance $1455 r0 *1 2266.19,2780.8 N
M$1455 VSS \$4641 \$I332242 VSS N L=1.2U W=30U AS=71.625P AD=71.625P PS=56.6U
+ PD=56.6U
* device instance $1459 r0 *1 2266.39,2805.85 P
M$1459 \$18 \$4641 \$I332242 \$18 P L=1.5U W=60U AS=144P AD=143.25P PS=94.2U
+ PD=94.1U
* device instance $1463 r0 *1 2293.94,2804.6 P
M$1463 \$18 \$I332242 \$4384 \$18 P L=1.5U W=50U AS=120P AD=119.375P PS=81.7U
+ PD=81.6U
* device instance $1467 r0 *1 2353.85,2783.575 N
M$1467 VSS \$I332243 \$3742 VSS N L=1.2U W=25U AS=59.6875P AD=59.6875P
+ PS=50.35U PD=50.35U
* device instance $1471 r0 *1 2325,2780.8 N
M$1471 VSS \$4644 \$I332243 VSS N L=1.2U W=30U AS=71.625P AD=71.625P PS=56.6U
+ PD=56.6U
* device instance $1475 r0 *1 2325.2,2805.85 P
M$1475 \$18 \$4644 \$I332243 \$18 P L=1.5U W=60U AS=144P AD=143.25P PS=94.2U
+ PD=94.1U
* device instance $1479 r0 *1 2352.75,2804.6 P
M$1479 \$18 \$I332243 \$3742 \$18 P L=1.5U W=50U AS=120P AD=119.375P PS=81.7U
+ PD=81.6U
* device instance $1483 r0 *1 279.46,3493.175 N
M$1483 VSS \$I332244 \$7041 VSS N L=1.2U W=25U AS=59.6875P AD=59.6875P
+ PS=50.35U PD=50.35U
* device instance $1487 r0 *1 250.61,3490.4 N
M$1487 VSS \$6963 \$I332244 VSS N L=1.2U W=30U AS=71.625P AD=71.625P PS=56.6U
+ PD=56.6U
* device instance $1491 r0 *1 250.81,3515.45 P
M$1491 \$18 \$6963 \$I332244 \$18 P L=1.5U W=60U AS=144P AD=143.25P PS=94.2U
+ PD=94.1U
* device instance $1495 r0 *1 278.36,3514.2 P
M$1495 \$18 \$I332244 \$7041 \$18 P L=1.5U W=50U AS=120P AD=119.375P PS=81.7U
+ PD=81.6U
* device instance $1499 m90 *1 1477.03,4025.375 N
M$1499 VSS \$I332245 \$8984 VSS N L=1.2U W=25U AS=59.6875P AD=59.6875P
+ PS=50.35U PD=50.35U
* device instance $1503 m90 *1 1505.88,4022.6 N
M$1503 VSS \$8985 \$I332245 VSS N L=1.2U W=30U AS=71.625P AD=71.625P PS=56.6U
+ PD=56.6U
* device instance $1507 m90 *1 1505.68,4047.65 P
M$1507 \$18 \$8985 \$I332245 \$18 P L=1.5U W=60U AS=144P AD=143.25P PS=94.2U
+ PD=94.1U
* device instance $1511 m90 *1 1478.13,4046.4 P
M$1511 \$18 \$I332245 \$8984 \$18 P L=1.5U W=50U AS=120P AD=119.375P PS=81.7U
+ PD=81.6U
* device instance $1515 r0 *1 3913.17,1009.575 N
M$1515 VSS \$I332246 \$1128 VSS N L=1.2U W=25U AS=59.6875P AD=59.6875P
+ PS=50.35U PD=50.35U
* device instance $1519 r0 *1 3884.32,1006.8 N
M$1519 VSS \$1033 \$I332246 VSS N L=1.2U W=30U AS=71.625P AD=71.625P PS=56.6U
+ PD=56.6U
* device instance $1523 r0 *1 3884.52,1031.85 P
M$1523 \$18 \$1033 \$I332246 \$18 P L=1.5U W=60U AS=144P AD=143.25P PS=94.2U
+ PD=94.1U
* device instance $1527 r0 *1 3912.07,1030.6 P
M$1527 \$18 \$I332246 \$1128 \$18 P L=1.5U W=50U AS=120P AD=119.375P PS=81.7U
+ PD=81.6U
* device instance $1531 r0 *1 4099.86,1009.575 N
M$1531 VSS \$I332247 \$1036 VSS N L=1.2U W=25U AS=59.6875P AD=59.6875P
+ PS=50.35U PD=50.35U
* device instance $1535 r0 *1 4071.01,1006.8 N
M$1535 VSS \$931 \$I332247 VSS N L=1.2U W=30U AS=71.625P AD=71.625P PS=56.6U
+ PD=56.6U
* device instance $1539 r0 *1 4071.21,1031.85 P
M$1539 \$18 \$931 \$I332247 \$18 P L=1.5U W=60U AS=144P AD=143.25P PS=94.2U
+ PD=94.1U
* device instance $1543 r0 *1 4098.76,1030.6 P
M$1543 \$18 \$I332247 \$1036 \$18 P L=1.5U W=50U AS=120P AD=119.375P PS=81.7U
+ PD=81.6U
* device instance $1547 m90 *1 4850.49,477.375 N
M$1547 VSS \$I332248 \$532 VSS N L=1.2U W=25U AS=59.6875P AD=59.6875P PS=50.35U
+ PD=50.35U
* device instance $1551 m90 *1 4879.34,474.6 N
M$1551 VSS \$595 \$I332248 VSS N L=1.2U W=30U AS=71.625P AD=71.625P PS=56.6U
+ PD=56.6U
* device instance $1555 m90 *1 4879.14,499.65 P
M$1555 \$18 \$595 \$I332248 \$18 P L=1.5U W=60U AS=144P AD=143.25P PS=94.2U
+ PD=94.1U
* device instance $1559 m90 *1 4851.59,498.4 P
M$1559 \$18 \$I332248 \$532 \$18 P L=1.5U W=50U AS=120P AD=119.375P PS=81.7U
+ PD=81.6U
* device instance $1563 m90 *1 5108.75,1541.775 N
M$1563 VSS \$I332249 \$1858 VSS N L=1.2U W=25U AS=59.6875P AD=59.6875P
+ PS=50.35U PD=50.35U
* device instance $1567 m90 *1 5137.6,1539 N
M$1567 VSS \$2012 \$I332249 VSS N L=1.2U W=30U AS=71.625P AD=71.625P PS=56.6U
+ PD=56.6U
* device instance $1571 m90 *1 5137.4,1564.05 P
M$1571 \$18 \$2012 \$I332249 \$18 P L=1.5U W=60U AS=144P AD=143.25P PS=94.2U
+ PD=94.1U
* device instance $1575 m90 *1 5109.85,1562.8 P
M$1575 \$18 \$I332249 \$1858 \$18 P L=1.5U W=50U AS=120P AD=119.375P PS=81.7U
+ PD=81.6U
* device instance $1579 r0 *1 4024.43,1186.975 N
M$1579 VSS \$I332250 \$1433 VSS N L=1.2U W=25U AS=59.6875P AD=59.6875P
+ PS=50.35U PD=50.35U
* device instance $1583 r0 *1 3995.58,1184.2 N
M$1583 VSS \$1360 \$I332250 VSS N L=1.2U W=30U AS=71.625P AD=71.625P PS=56.6U
+ PD=56.6U
* device instance $1587 r0 *1 3995.78,1209.25 P
M$1587 \$18 \$1360 \$I332250 \$18 P L=1.5U W=60U AS=144P AD=143.25P PS=94.2U
+ PD=94.1U
* device instance $1591 r0 *1 4023.33,1208 P
M$1591 \$18 \$I332250 \$1433 \$18 P L=1.5U W=50U AS=120P AD=119.375P PS=81.7U
+ PD=81.6U
* device instance $1595 r0 *1 4079.8,1186.975 N
M$1595 VSS \$I332251 \$1360 VSS N L=1.2U W=25U AS=59.6875P AD=59.6875P
+ PS=50.35U PD=50.35U
* device instance $1599 r0 *1 4050.95,1184.2 N
M$1599 VSS \$934 \$I332251 VSS N L=1.2U W=30U AS=71.625P AD=71.625P PS=56.6U
+ PD=56.6U
* device instance $1603 r0 *1 4051.15,1209.25 P
M$1603 \$18 \$934 \$I332251 \$18 P L=1.5U W=60U AS=144P AD=143.25P PS=94.2U
+ PD=94.1U
* device instance $1607 r0 *1 4078.7,1208 P
M$1607 \$18 \$I332251 \$1360 \$18 P L=1.5U W=50U AS=120P AD=119.375P PS=81.7U
+ PD=81.6U
* device instance $1611 r0 *1 4027.88,1719.175 N
M$1611 VSS \$I332252 \$2260 VSS N L=1.2U W=25U AS=59.6875P AD=59.6875P
+ PS=50.35U PD=50.35U
* device instance $1615 r0 *1 3999.03,1716.4 N
M$1615 VSS \$2124 \$I332252 VSS N L=1.2U W=30U AS=71.625P AD=71.625P PS=56.6U
+ PD=56.6U
* device instance $1619 r0 *1 3999.23,1741.45 P
M$1619 \$18 \$2124 \$I332252 \$18 P L=1.5U W=60U AS=144P AD=143.25P PS=94.2U
+ PD=94.1U
* device instance $1623 r0 *1 4026.78,1740.2 P
M$1623 \$18 \$I332252 \$2260 \$18 P L=1.5U W=50U AS=120P AD=119.375P PS=81.7U
+ PD=81.6U
* device instance $1627 r0 *1 4116.75,1719.175 N
M$1627 VSS \$I332253 \$1974 VSS N L=1.2U W=25U AS=59.6875P AD=59.6875P
+ PS=50.35U PD=50.35U
* device instance $1631 r0 *1 4087.9,1716.4 N
M$1631 VSS \$2260 \$I332253 VSS N L=1.2U W=30U AS=71.625P AD=71.625P PS=56.6U
+ PD=56.6U
* device instance $1635 r0 *1 4088.1,1741.45 P
M$1635 \$18 \$2260 \$I332253 \$18 P L=1.5U W=60U AS=144P AD=143.25P PS=94.2U
+ PD=94.1U
* device instance $1639 r0 *1 4115.65,1740.2 P
M$1639 \$18 \$I332253 \$1974 \$18 P L=1.5U W=50U AS=120P AD=119.375P PS=81.7U
+ PD=81.6U
* device instance $1643 r0 *1 4346.8,1719.175 N
M$1643 VSS \$I332254 \$1993 VSS N L=1.2U W=25U AS=59.6875P AD=59.6875P
+ PS=50.35U PD=50.35U
* device instance $1647 r0 *1 4317.95,1716.4 N
M$1647 VSS \$2225 \$I332254 VSS N L=1.2U W=30U AS=71.625P AD=71.625P PS=56.6U
+ PD=56.6U
* device instance $1651 r0 *1 4318.15,1741.45 P
M$1651 \$18 \$2225 \$I332254 \$18 P L=1.5U W=60U AS=144P AD=143.25P PS=94.2U
+ PD=94.1U
* device instance $1655 r0 *1 4345.7,1740.2 P
M$1655 \$18 \$I332254 \$1993 \$18 P L=1.5U W=50U AS=120P AD=119.375P PS=81.7U
+ PD=81.6U
* device instance $1659 r0 *1 4950.9,1719.175 N
M$1659 VSS \$I332255 \$2194 VSS N L=1.2U W=25U AS=59.6875P AD=59.6875P
+ PS=50.35U PD=50.35U
* device instance $1663 r0 *1 4922.05,1716.4 N
M$1663 VSS \$2306 \$I332255 VSS N L=1.2U W=30U AS=71.625P AD=71.625P PS=56.6U
+ PD=56.6U
* device instance $1667 r0 *1 4922.25,1741.45 P
M$1667 \$18 \$2306 \$I332255 \$18 P L=1.5U W=60U AS=144P AD=143.25P PS=94.2U
+ PD=94.1U
* device instance $1671 r0 *1 4949.8,1740.2 P
M$1671 \$18 \$I332255 \$2194 \$18 P L=1.5U W=50U AS=120P AD=119.375P PS=81.7U
+ PD=81.6U
* device instance $1675 r0 *1 4181.5,1896.575 N
M$1675 VSS \$I332256 \$1879 VSS N L=1.2U W=25U AS=59.6875P AD=59.6875P
+ PS=50.35U PD=50.35U
* device instance $1679 r0 *1 4152.65,1893.8 N
M$1679 VSS \$2350 \$I332256 VSS N L=1.2U W=30U AS=71.625P AD=71.625P PS=56.6U
+ PD=56.6U
* device instance $1683 r0 *1 4152.85,1918.85 P
M$1683 \$18 \$2350 \$I332256 \$18 P L=1.5U W=60U AS=144P AD=143.25P PS=94.2U
+ PD=94.1U
* device instance $1687 r0 *1 4180.4,1917.6 P
M$1687 \$18 \$I332256 \$1879 \$18 P L=1.5U W=50U AS=120P AD=119.375P PS=81.7U
+ PD=81.6U
* device instance $1691 r0 *1 4359.66,1896.575 N
M$1691 VSS \$I332257 \$2518 VSS N L=1.2U W=25U AS=59.6875P AD=59.6875P
+ PS=50.35U PD=50.35U
* device instance $1695 r0 *1 4330.81,1893.8 N
M$1695 VSS \$2556 \$I332257 VSS N L=1.2U W=30U AS=71.625P AD=71.625P PS=56.6U
+ PD=56.6U
* device instance $1699 r0 *1 4331.01,1918.85 P
M$1699 \$18 \$2556 \$I332257 \$18 P L=1.5U W=60U AS=144P AD=143.25P PS=94.2U
+ PD=94.1U
* device instance $1703 r0 *1 4358.56,1917.6 P
M$1703 \$18 \$I332257 \$2518 \$18 P L=1.5U W=50U AS=120P AD=119.375P PS=81.7U
+ PD=81.6U
* device instance $1707 r0 *1 5002.41,8460.375 N
M$1707 VSS \$I332258 \$20299 VSS N L=1.2U W=25U AS=59.6875P AD=59.6875P
+ PS=50.35U PD=50.35U
* device instance $1711 r0 *1 4973.56,8457.6 N
M$1711 VSS \$20300 \$I332258 VSS N L=1.2U W=30U AS=71.625P AD=71.625P PS=56.6U
+ PD=56.6U
* device instance $1715 r0 *1 4973.76,8482.65 P
M$1715 \$18 \$20300 \$I332258 \$18 P L=1.5U W=60U AS=144P AD=143.25P PS=94.2U
+ PD=94.1U
* device instance $1719 r0 *1 5001.31,8481.4 P
M$1719 \$18 \$I332258 \$20299 \$18 P L=1.5U W=50U AS=120P AD=119.375P PS=81.7U
+ PD=81.6U
* device instance $1723 r0 *1 2430.73,4557.575 N
M$1723 VSS \$I332259 \$12452 VSS N L=1.2U W=25U AS=59.6875P AD=59.6875P
+ PS=50.35U PD=50.35U
* device instance $1727 r0 *1 2401.88,4554.8 N
M$1727 VSS \$10607 \$I332259 VSS N L=1.2U W=30U AS=71.625P AD=71.625P PS=56.6U
+ PD=56.6U
* device instance $1731 r0 *1 2402.08,4579.85 P
M$1731 \$18 \$10607 \$I332259 \$18 P L=1.5U W=60U AS=144P AD=143.25P PS=94.2U
+ PD=94.1U
* device instance $1735 r0 *1 2429.63,4578.6 P
M$1735 \$18 \$I332259 \$12452 \$18 P L=1.5U W=50U AS=120P AD=119.375P PS=81.7U
+ PD=81.6U
* device instance $1739 r0 *1 3230.81,4557.575 N
M$1739 VSS \$I332260 \$11738 VSS N L=1.2U W=25U AS=59.6875P AD=59.6875P
+ PS=50.35U PD=50.35U
* device instance $1743 r0 *1 3201.96,4554.8 N
M$1743 VSS \$12482 \$I332260 VSS N L=1.2U W=30U AS=71.625P AD=71.625P PS=56.6U
+ PD=56.6U
* device instance $1747 r0 *1 3202.16,4579.85 P
M$1747 \$18 \$12482 \$I332260 \$18 P L=1.5U W=60U AS=144P AD=143.25P PS=94.2U
+ PD=94.1U
* device instance $1751 r0 *1 3229.71,4578.6 P
M$1751 \$18 \$I332260 \$11738 \$18 P L=1.5U W=50U AS=120P AD=119.375P PS=81.7U
+ PD=81.6U
* device instance $1755 r0 *1 6014.59,4557.575 N
M$1755 VSS \$I332261 \$11971 VSS N L=1.2U W=25U AS=59.6875P AD=59.6875P
+ PS=50.35U PD=50.35U
* device instance $1759 r0 *1 5985.74,4554.8 N
M$1759 VSS \$10716 \$I332261 VSS N L=1.2U W=30U AS=71.625P AD=71.625P PS=56.6U
+ PD=56.6U
* device instance $1763 r0 *1 5985.94,4579.85 P
M$1763 \$18 \$10716 \$I332261 \$18 P L=1.5U W=60U AS=144P AD=143.25P PS=94.2U
+ PD=94.1U
* device instance $1767 r0 *1 6013.49,4578.6 P
M$1767 \$18 \$I332261 \$11971 \$18 P L=1.5U W=50U AS=120P AD=119.375P PS=81.7U
+ PD=81.6U
* device instance $1771 r0 *1 6411.91,4557.575 N
M$1771 VSS \$I332262 \$11985 VSS N L=1.2U W=25U AS=59.6875P AD=59.6875P
+ PS=50.35U PD=50.35U
* device instance $1775 r0 *1 6383.06,4554.8 N
M$1775 VSS \$12533 \$I332262 VSS N L=1.2U W=30U AS=71.625P AD=71.625P PS=56.6U
+ PD=56.6U
* device instance $1779 r0 *1 6383.26,4579.85 P
M$1779 \$18 \$12533 \$I332262 \$18 P L=1.5U W=60U AS=144P AD=143.25P PS=94.2U
+ PD=94.1U
* device instance $1783 r0 *1 6410.81,4578.6 P
M$1783 \$18 \$I332262 \$11985 \$18 P L=1.5U W=50U AS=120P AD=119.375P PS=81.7U
+ PD=81.6U
* device instance $1787 m0 *1 1115.91,4667.225 N
M$1787 VSS \$I332263 \$10039 VSS N L=1.2U W=25U AS=59.6875P AD=59.6875P
+ PS=50.35U PD=50.35U
* device instance $1791 m0 *1 1087.06,4670 N
M$1791 VSS \$12890 \$I332263 VSS N L=1.2U W=30U AS=71.625P AD=71.625P PS=56.6U
+ PD=56.6U
* device instance $1795 m0 *1 1087.26,4644.95 P
M$1795 \$18 \$12890 \$I332263 \$18 P L=1.5U W=60U AS=144P AD=143.25P PS=94.2U
+ PD=94.1U
* device instance $1799 m0 *1 1114.81,4646.2 P
M$1799 \$18 \$I332263 \$10039 \$18 P L=1.5U W=50U AS=120P AD=119.375P PS=81.7U
+ PD=81.6U
* device instance $1803 m0 *1 1869.14,4667.225 N
M$1803 VSS \$I332264 \$12911 VSS N L=1.2U W=25U AS=59.6875P AD=59.6875P
+ PS=50.35U PD=50.35U
* device instance $1807 m0 *1 1840.29,4670 N
M$1807 VSS \$12910 \$I332264 VSS N L=1.2U W=30U AS=71.625P AD=71.625P PS=56.6U
+ PD=56.6U
* device instance $1811 m0 *1 1840.49,4644.95 P
M$1811 \$18 \$12910 \$I332264 \$18 P L=1.5U W=60U AS=144P AD=143.25P PS=94.2U
+ PD=94.1U
* device instance $1815 m0 *1 1868.04,4646.2 P
M$1815 \$18 \$I332264 \$12911 \$18 P L=1.5U W=50U AS=120P AD=119.375P PS=81.7U
+ PD=81.6U
* device instance $1819 m0 *1 1923.74,4667.225 N
M$1819 VSS \$I332265 \$12913 VSS N L=1.2U W=25U AS=59.6875P AD=59.6875P
+ PS=50.35U PD=50.35U
* device instance $1823 m0 *1 1894.89,4670 N
M$1823 VSS \$12912 \$I332265 VSS N L=1.2U W=30U AS=71.625P AD=71.625P PS=56.6U
+ PD=56.6U
* device instance $1827 m0 *1 1895.09,4644.95 P
M$1827 \$18 \$12912 \$I332265 \$18 P L=1.5U W=60U AS=144P AD=143.25P PS=94.2U
+ PD=94.1U
* device instance $1831 m0 *1 1922.64,4646.2 P
M$1831 \$18 \$I332265 \$12913 \$18 P L=1.5U W=50U AS=120P AD=119.375P PS=81.7U
+ PD=81.6U
* device instance $1835 m0 *1 3323.92,4667.225 N
M$1835 VSS \$I332266 \$12950 VSS N L=1.2U W=25U AS=59.6875P AD=59.6875P
+ PS=50.35U PD=50.35U
* device instance $1839 m0 *1 3295.07,4670 N
M$1839 VSS \$12949 \$I332266 VSS N L=1.2U W=30U AS=71.625P AD=71.625P PS=56.6U
+ PD=56.6U
* device instance $1843 m0 *1 3295.27,4644.95 P
M$1843 \$18 \$12949 \$I332266 \$18 P L=1.5U W=60U AS=144P AD=143.25P PS=94.2U
+ PD=94.1U
* device instance $1847 m0 *1 3322.82,4646.2 P
M$1847 \$18 \$I332266 \$12950 \$18 P L=1.5U W=50U AS=120P AD=119.375P PS=81.7U
+ PD=81.6U
* device instance $1851 m0 *1 5066.66,4667.225 N
M$1851 VSS \$I332267 \$12499 VSS N L=1.2U W=25U AS=59.6875P AD=59.6875P
+ PS=50.35U PD=50.35U
* device instance $1855 m0 *1 5037.81,4670 N
M$1855 VSS \$12348 \$I332267 VSS N L=1.2U W=30U AS=71.625P AD=71.625P PS=56.6U
+ PD=56.6U
* device instance $1859 m0 *1 5038.01,4644.95 P
M$1859 \$18 \$12348 \$I332267 \$18 P L=1.5U W=60U AS=144P AD=143.25P PS=94.2U
+ PD=94.1U
* device instance $1863 m0 *1 5065.56,4646.2 P
M$1863 \$18 \$I332267 \$12499 \$18 P L=1.5U W=50U AS=120P AD=119.375P PS=81.7U
+ PD=81.6U
* device instance $1867 m0 *1 1758.85,4312.425 N
M$1867 VSS \$I332268 \$10604 VSS N L=1.2U W=25U AS=59.6875P AD=59.6875P
+ PS=50.35U PD=50.35U
* device instance $1871 m0 *1 1730,4315.2 N
M$1871 VSS \$10216 \$I332268 VSS N L=1.2U W=30U AS=71.625P AD=71.625P PS=56.6U
+ PD=56.6U
* device instance $1875 m0 *1 1730.2,4290.15 P
M$1875 \$18 \$10216 \$I332268 \$18 P L=1.5U W=60U AS=144P AD=143.25P PS=94.2U
+ PD=94.1U
* device instance $1879 m0 *1 1757.75,4291.4 P
M$1879 \$18 \$I332268 \$10604 \$18 P L=1.5U W=50U AS=120P AD=119.375P PS=81.7U
+ PD=81.6U
* device instance $1883 m0 *1 6179.16,4312.425 N
M$1883 VSS \$I332269 \$10716 VSS N L=1.2U W=25U AS=59.6875P AD=59.6875P
+ PS=50.35U PD=50.35U
* device instance $1887 m0 *1 6150.31,4315.2 N
M$1887 VSS \$9575 \$I332269 VSS N L=1.2U W=30U AS=71.625P AD=71.625P PS=56.6U
+ PD=56.6U
* device instance $1891 m0 *1 6150.51,4290.15 P
M$1891 \$18 \$9575 \$I332269 \$18 P L=1.5U W=60U AS=144P AD=143.25P PS=94.2U
+ PD=94.1U
* device instance $1895 m0 *1 6178.06,4291.4 P
M$1895 \$18 \$I332269 \$10716 \$18 P L=1.5U W=50U AS=120P AD=119.375P PS=81.7U
+ PD=81.6U
* device instance $1899 m0 *1 2747.2,3957.625 N
M$1899 VSS \$I332270 \$8605 VSS N L=1.2U W=25U AS=59.6875P AD=59.6875P
+ PS=50.35U PD=50.35U
* device instance $1903 m0 *1 2718.35,3960.4 N
M$1903 VSS \$9016 \$I332270 VSS N L=1.2U W=30U AS=71.625P AD=71.625P PS=56.6U
+ PD=56.6U
* device instance $1907 m0 *1 2718.55,3935.35 P
M$1907 \$18 \$9016 \$I332270 \$18 P L=1.5U W=60U AS=144P AD=143.25P PS=94.2U
+ PD=94.1U
* device instance $1911 m0 *1 2746.1,3936.6 P
M$1911 \$18 \$I332270 \$8605 \$18 P L=1.5U W=50U AS=120P AD=119.375P PS=81.7U
+ PD=81.6U
* device instance $1915 r0 *1 1797.84,4380.175 N
M$1915 VSS \$I332271 \$11155 VSS N L=1.2U W=25U AS=59.6875P AD=59.6875P
+ PS=50.35U PD=50.35U
* device instance $1919 r0 *1 1768.99,4377.4 N
M$1919 VSS \$11365 \$I332271 VSS N L=1.2U W=30U AS=71.625P AD=71.625P PS=56.6U
+ PD=56.6U
* device instance $1923 r0 *1 1769.19,4402.45 P
M$1923 \$18 \$11365 \$I332271 \$18 P L=1.5U W=60U AS=144P AD=143.25P PS=94.2U
+ PD=94.1U
* device instance $1927 r0 *1 1796.74,4401.2 P
M$1927 \$18 \$I332271 \$11155 \$18 P L=1.5U W=50U AS=120P AD=119.375P PS=81.7U
+ PD=81.6U
* device instance $1931 r0 *1 5393.06,4380.175 N
M$1931 VSS \$I332272 \$10869 VSS N L=1.2U W=25U AS=59.6875P AD=59.6875P
+ PS=50.35U PD=50.35U
* device instance $1935 r0 *1 5364.21,4377.4 N
M$1935 VSS \$11259 \$I332272 VSS N L=1.2U W=30U AS=71.625P AD=71.625P PS=56.6U
+ PD=56.6U
* device instance $1939 r0 *1 5364.41,4402.45 P
M$1939 \$18 \$11259 \$I332272 \$18 P L=1.5U W=60U AS=144P AD=143.25P PS=94.2U
+ PD=94.1U
* device instance $1943 r0 *1 5391.96,4401.2 P
M$1943 \$18 \$I332272 \$10869 \$18 P L=1.5U W=50U AS=120P AD=119.375P PS=81.7U
+ PD=81.6U
.ENDS top

* cell AND801
* pin IN1
* pin IN2
* pin IN3
* pin IN4
* pin IN8
* pin IN7
* pin IN6
* pin IN5
* pin OUT1
* pin VDD
* pin VSS
.SUBCKT AND801 IN1 IN2 IN3 IN4 IN8 IN7 IN6 IN5 OUT1 VDD VSS
* device instance $1 r0 *1 65.1,11.05 N
M$1 VSS \$12 \$13 VSS N L=1.2U W=6U AS=22.2P AD=13.575P PS=19.4U PD=11.5U
* device instance $2 r0 *1 70.3,11.8 N
M$2 OUT1 \$13 VSS VSS N L=1.2U W=7.5U AS=13.575P AD=27.75P PS=11.5U PD=22.4U
* device instance $3 r0 *1 49.55,10.55 N
M$3 \$12 \$10 VSS VSS N L=1.2U W=7U AS=25.9P AD=13.825P PS=21.4U PD=10.95U
* device instance $4 r0 *1 54.7,10.55 N
M$4 VSS \$11 \$12 VSS N L=1.2U W=7U AS=13.825P AD=25.9P PS=10.95U PD=21.4U
* device instance $5 r0 *1 27,9.5 N
M$5 \$18 IN8 VSS VSS N L=1.2U W=8U AS=29.6P AD=8P PS=23.4U PD=10U
* device instance $6 r0 *1 30.2,9.5 N
M$6 \$19 IN7 \$18 VSS N L=1.2U W=8U AS=8P AD=13.6P PS=10U PD=11.4U
* device instance $7 r0 *1 34.8,9.5 N
M$7 \$20 IN6 \$19 VSS N L=1.2U W=8U AS=13.6P AD=8P PS=11.4U PD=10U
* device instance $8 r0 *1 38,9.5 N
M$8 \$11 IN5 \$20 VSS N L=1.2U W=8U AS=8P AD=30P PS=10U PD=23.5U
* device instance $9 r0 *1 5.15,9.5 N
M$9 \$15 IN1 \$10 VSS N L=1.2U W=8U AS=29.6P AD=8P PS=23.4U PD=10U
* device instance $10 r0 *1 8.35,9.5 N
M$10 \$16 IN2 \$15 VSS N L=1.2U W=8U AS=8P AD=8P PS=10U PD=10U
* device instance $11 r0 *1 11.55,9.5 N
M$11 \$17 IN3 \$16 VSS N L=1.2U W=8U AS=8P AD=8P PS=10U PD=10U
* device instance $12 r0 *1 14.75,9.5 N
M$12 VSS IN4 \$17 VSS N L=1.2U W=8U AS=8P AD=30P PS=10U PD=23.5U
* device instance $13 r0 *1 5.3,36.8 P
M$13 \$10 IN1 VDD VDD P L=1.5U W=13U AS=48.1P AD=25.35P PS=33.4U PD=16.9U
* device instance $14 r0 *1 10.7,36.8 P
M$14 VDD IN2 \$10 VDD P L=1.5U W=13U AS=25.35P AD=25.35P PS=16.9U PD=16.9U
* device instance $15 r0 *1 16.1,36.8 P
M$15 \$10 IN3 VDD VDD P L=1.5U W=13U AS=25.35P AD=25.35P PS=16.9U PD=16.9U
* device instance $16 r0 *1 21.5,36.8 P
M$16 VDD IN4 \$10 VDD P L=1.5U W=13U AS=25.35P AD=25.35P PS=16.9U PD=16.9U
* device instance $17 r0 *1 26.9,36.8 P
M$17 \$11 IN8 VDD VDD P L=1.5U W=13U AS=25.35P AD=25.35P PS=16.9U PD=16.9U
* device instance $18 r0 *1 32.3,36.8 P
M$18 VDD IN7 \$11 VDD P L=1.5U W=13U AS=25.35P AD=25.35P PS=16.9U PD=16.9U
* device instance $19 r0 *1 37.7,36.8 P
M$19 \$11 IN6 VDD VDD P L=1.5U W=13U AS=25.35P AD=25.35P PS=16.9U PD=16.9U
* device instance $20 r0 *1 43.1,36.8 P
M$20 VDD IN5 \$11 VDD P L=1.5U W=13U AS=25.35P AD=27P PS=16.9U PD=18U
* device instance $21 r0 *1 48.6,37.3 P
M$21 \$22 \$10 VDD VDD P L=1.5U W=14U AS=27P AD=13.65P PS=18U PD=15.95U
* device instance $22 r0 *1 52.05,37.3 P
M$22 \$12 \$11 \$22 VDD P L=1.5U W=14U AS=13.65P AD=51.8P PS=15.95U PD=35.4U
* device instance $23 r0 *1 64.7,37.7 P
M$23 \$13 \$12 VDD VDD P L=1.5U W=11U AS=25.725P AD=40.7P PS=18.95U PD=29.4U
* device instance $24 r0 *1 70.15,35.7 P
M$24 OUT1 \$13 VDD VDD P L=1.5U W=15U AS=25.725P AD=55.5P PS=18.95U PD=37.4U
.ENDS AND801

* cell NOR601
* pin IN3
* pin IN2
* pin IN1
* pin IN6
* pin OUT1
* pin IN5
* pin
* pin VDD
* pin VSS
.SUBCKT NOR601 IN3 IN2 IN1 IN6 OUT1 IN5 \$12 VDD VSS
* device instance $1 r0 *1 34.05,12.5 N
M$1 VSS \$12 \$8 VSS N L=1.2U W=8U AS=30.4P AD=15.6P PS=23.6U PD=11.9U
* device instance $2 r0 *1 39.15,12.5 N
M$2 \$8 IN5 VSS VSS N L=1.2U W=8U AS=15.6P AD=15.6P PS=11.9U PD=11.9U
* device instance $3 r0 *1 44.25,12.5 N
M$3 VSS IN6 \$8 VSS N L=1.2U W=8U AS=15.6P AD=16.15P PS=11.9U PD=12.1U
* device instance $4 r0 *1 49.55,13 N
M$4 OUT1 \$7 VSS VSS N L=1.2U W=7U AS=16.15P AD=25.9P PS=12.1U PD=21.4U
* device instance $5 r0 *1 5.15,12.5 N
M$5 VSS IN3 \$6 VSS N L=1.2U W=8U AS=29.6P AD=15.6P PS=23.4U PD=11.9U
* device instance $6 r0 *1 10.25,12.5 N
M$6 \$6 IN2 VSS VSS N L=1.2U W=8U AS=15.6P AD=15.6P PS=11.9U PD=11.9U
* device instance $7 r0 *1 15.35,12.5 N
M$7 \$6 IN1 VSS VSS N L=1.2U W=8U AS=28.875P AD=15.6P PS=17.3U PD=11.9U
* device instance $8 r0 *1 21.35,10.25 N
M$8 \$10 \$6 VSS VSS N L=1.2U W=12.5U AS=28.875P AD=8.125P PS=17.3U PD=13.8U
* device instance $9 r0 *1 23.85,10.25 N
M$9 \$7 \$8 \$10 VSS N L=1.2U W=12.5U AS=8.125P AD=46.25P PS=13.8U PD=32.4U
* device instance $10 r0 *1 37.25,33.2 P
M$10 \$18 \$12 \$8 VDD P L=1.5U W=14U AS=51.8P AD=12.6P PS=35.4U PD=15.8U
* device instance $11 r0 *1 40.55,33.2 P
M$11 \$17 IN5 \$18 VDD P L=1.5U W=14U AS=12.6P AD=11.55P PS=15.8U PD=15.65U
* device instance $12 r0 *1 43.7,33.2 P
M$12 \$17 IN6 VDD VDD P L=1.5U W=14U AS=33.1P AD=11.55P PS=20.2U PD=15.65U
* device instance $13 r0 *1 49.4,32.7 P
M$13 OUT1 \$7 VDD VDD P L=1.5U W=16U AS=33.1P AD=59.2P PS=20.2U PD=39.4U
* device instance $14 r0 *1 18,34.2 P
M$14 \$7 \$6 VDD VDD P L=1.5U W=10U AS=28.4P AD=22.75P PS=18.2U PD=14.55U
* device instance $15 r0 *1 24.05,34.2 P
M$15 VDD \$8 \$7 VDD P L=1.5U W=10U AS=22.75P AD=40P PS=14.55U PD=28U
* device instance $16 r0 *1 5.3,33.2 P
M$16 \$16 IN3 \$6 VDD P L=1.5U W=14U AS=51.8P AD=14P PS=35.4U PD=16U
* device instance $17 r0 *1 8.8,33.2 P
M$17 \$15 IN2 \$16 VDD P L=1.5U W=14U AS=14P AD=14P PS=16U PD=16U
* device instance $18 r0 *1 12.3,33.2 P
M$18 VDD IN1 \$15 VDD P L=1.5U W=14U AS=14P AD=28.4P PS=16U PD=18.2U
.ENDS NOR601

* cell NOR200
* pin OUT1
* pin VDD
* pin IN2
* pin IN1
* pin VSS
.SUBCKT NOR200 OUT1 VDD IN2 IN1 VSS
* device instance $1 r0 *1 6,10.25 N
M$1 VSS IN1 OUT1 VSS N L=1.2U W=6.5U AS=24.05P AD=12.675P PS=20.4U PD=10.4U
* device instance $2 r0 *1 11.1,10.25 N
M$2 OUT1 IN2 VSS VSS N L=1.2U W=6.5U AS=12.675P AD=24.05P PS=10.4U PD=20.4U
* device instance $3 r0 *1 11.65,33.15 P
M$3 OUT1 IN2 \$6 VDD P L=1.5U W=19U AS=28.0075P AD=51.06P PS=26.2U PD=35U
* device instance $4 r0 *1 6.3,35 P
M$4 \$6 IN1 VDD VDD P L=1.5U W=19U AS=70.3P AD=28.0075P PS=45.4U PD=26.2U
.ENDS NOR200

* cell ADOR16
* pin C
* pin D
* pin A
* pin E
* pin F
* pin OUT1
* pin B
* pin VDD
* pin VSS
.SUBCKT ADOR16 C D A E F OUT1 B VDD VSS
* device instance $1 r0 *1 34.05,12.6 N
M$1 \$11 E \$5 VSS N L=1.2U W=8U AS=29.6P AD=8P PS=23.4U PD=10U
* device instance $2 r0 *1 37.25,12.6 N
M$2 \$11 F VSS VSS N L=1.2U W=8U AS=46.2075P AD=8P PS=25.35U PD=10U
* device instance $3 r0 *1 45.95,11.7 N
M$3 OUT1 \$5 VSS VSS N L=1.2U W=15U AS=46.2075P AD=37.875P PS=25.35U PD=27.6U
* device instance $4 r0 *1 5.45,12 N
M$4 \$9 B VSS VSS N L=1.2U W=8U AS=29.6P AD=11P PS=23.4U PD=10.75U
* device instance $5 r0 *1 9.4,12 N
M$5 \$5 A \$9 VSS N L=1.2U W=8U AS=11P AD=15.8P PS=10.75U PD=11.95U
* device instance $6 r0 *1 14.55,12 N
M$6 \$10 C \$5 VSS N L=1.2U W=8U AS=15.8P AD=8P PS=11.95U PD=10U
* device instance $7 r0 *1 17.75,12 N
M$7 VSS D \$10 VSS N L=1.2U W=8U AS=8P AD=29.6P PS=10U PD=23.4U
* device instance $8 r0 *1 16.2,34.8 P
M$8 \$13 C \$14 VDD P L=1.5U W=18U AS=40.5P AD=37.8P PS=24.1U PD=22.2U
* device instance $9 r0 *1 21.9,34.8 P
M$9 \$14 D \$13 VDD P L=1.5U W=18U AS=37.8P AD=66.6P PS=22.2U PD=43.4U
* device instance $10 r0 *1 5.2,35.8 P
M$10 VDD B \$14 VDD P L=1.5U W=20U AS=74P AD=39P PS=47.4U PD=23.9U
* device instance $11 r0 *1 10.6,35.8 P
M$11 \$14 A VDD VDD P L=1.5U W=20U AS=39P AD=40.5P PS=23.9U PD=24.1U
* device instance $12 r0 *1 33,33.8 P
M$12 \$5 E \$13 VDD P L=1.5U W=16U AS=59.2P AD=33.6P PS=39.4U PD=20.2U
* device instance $13 r0 *1 38.7,33.8 P
M$13 \$13 F \$5 VDD P L=1.5U W=16U AS=33.6P AD=59.2P PS=20.2U PD=39.4U
* device instance $14 r0 *1 50.55,33.55 P
M$14 OUT1 \$5 VDD VDD P L=1.5U W=22U AS=100.64P AD=64.6P PS=61.8U PD=42.6U
.ENDS ADOR16

* cell ORND01
* pin VDD
* pin OUT1
* pin C
* pin B
* pin A
* pin VSS
.SUBCKT ORND01 VDD OUT1 C B A VSS
* device instance $1 r0 *1 18.45,11.5 N
M$1 OUT1 C \$7 VSS N L=1.2U W=10U AS=23.5P AD=37P PS=16U PD=27.4U
* device instance $2 r0 *1 8.05,11 N
M$2 VSS A \$7 VSS N L=1.2U W=12U AS=44.4P AD=24P PS=31.4U PD=16U
* device instance $3 r0 *1 13.25,11 N
M$3 \$7 B VSS VSS N L=1.2U W=12U AS=24P AD=23.5P PS=16U PD=16U
* device instance $4 r0 *1 7.3,33 P
M$4 VDD A \$6 VDD P L=1.5U W=24U AS=71.4P AD=65.6P PS=47.9U PD=40.4U
* device instance $6 r0 *1 24.1,36 P
M$6 VDD C OUT1 VDD P L=1.5U W=18U AS=37.1P AD=66.6P PS=23.9U PD=43.4U
* device instance $7 r0 *1 18.7,37 P
M$7 OUT1 B \$6 VDD P L=1.5U W=20U AS=42.2P AD=37.1P PS=24.5U PD=23.9U
.ENDS ORND01

* cell NOR501
* pin IN1
* pin IN5
* pin IN4
* pin IN3
* pin IN2
* pin OUT1
* pin VDD
* pin VSS
.SUBCKT NOR501 IN1 IN5 IN4 IN3 IN2 OUT1 VDD VSS
* device instance $1 r0 *1 29.75,10.5 N
M$1 VSS IN3 \$5 VSS N L=1.2U W=6U AS=22.2P AD=11.7P PS=19.4U PD=9.9U
* device instance $2 r0 *1 34.85,10.5 N
M$2 \$5 IN2 VSS VSS N L=1.2U W=6U AS=11.7P AD=11.7P PS=9.9U PD=9.9U
* device instance $3 r0 *1 39.95,10.5 N
M$3 VSS IN1 \$5 VSS N L=1.2U W=6U AS=11.7P AD=17.65P PS=9.9U PD=13.2U
* device instance $4 r0 *1 45.35,13 N
M$4 OUT1 \$7 VSS VSS N L=1.2U W=7U AS=17.65P AD=25.9P PS=13.2U PD=21.4U
* device instance $5 r0 *1 5.15,11.75 N
M$5 \$6 IN5 VSS VSS N L=1.2U W=3.5U AS=12.95P AD=6.825P PS=14.4U PD=7.4U
* device instance $6 r0 *1 10.25,11.75 N
M$6 \$6 IN4 VSS VSS N L=1.2U W=3.5U AS=15.675P AD=6.825P PS=12.2U PD=7.4U
* device instance $7 r0 *1 15.65,12.5 N
M$7 \$11 \$6 VSS VSS N L=1.2U W=8U AS=15.675P AD=5.2P PS=12.2U PD=9.3U
* device instance $8 r0 *1 18.15,12.5 N
M$8 \$7 \$5 \$11 VSS N L=1.2U W=8U AS=5.2P AD=29.6P PS=9.3U PD=23.4U
* device instance $9 r0 *1 34.2,33.7 P
M$9 \$14 IN3 \$5 VDD P L=1.5U W=16U AS=59.2P AD=10.4P PS=39.4U PD=17.3U
* device instance $10 r0 *1 37,33.7 P
M$10 \$15 IN2 \$14 VDD P L=1.5U W=16U AS=10.4P AD=10.4P PS=17.3U PD=17.3U
* device instance $11 r0 *1 39.8,33.7 P
M$11 VDD IN1 \$15 VDD P L=1.5U W=16U AS=10.4P AD=31.2P PS=17.3U PD=19.9U
* device instance $12 r0 *1 45.2,33.7 P
M$12 OUT1 \$7 VDD VDD P L=1.5U W=16U AS=31.2P AD=59.2P PS=19.9U PD=39.4U
* device instance $13 r0 *1 5.3,35.3 P
M$13 \$13 IN5 \$6 VDD P L=1.5U W=7U AS=25.9P AD=7P PS=21.4U PD=9U
* device instance $14 r0 *1 8.8,35.3 P
M$14 \$13 IN4 VDD VDD P L=1.5U W=7U AS=20.25P AD=7P PS=14.2U PD=9U
* device instance $15 r0 *1 14.5,33.8 P
M$15 \$7 \$6 VDD VDD P L=1.5U W=10U AS=20.25P AD=19.5P PS=14.2U PD=13.9U
* device instance $16 r0 *1 19.9,33.8 P
M$16 VDD \$5 \$7 VDD P L=1.5U W=10U AS=19.5P AD=37P PS=13.9U PD=27.4U
.ENDS NOR501

* cell PDDR02
* pin EN
* pin D
* pin P_EN
* pin VDD
* pin VSS
.SUBCKT PDDR02 EN D P_EN VDD VSS
* device instance $1 r0 *1 48.55,12.25 N
M$1 \$10 \$4 \$2 VSS N L=1.5U W=6.5U AS=24.05P AD=6.175P PS=20.4U PD=8.4U
* device instance $2 r0 *1 51.95,12.25 N
M$2 \$10 \$8 VSS VSS N L=1.5U W=6.5U AS=40.29P AD=6.175P PS=25.1U PD=8.4U
* device instance $3 r0 *1 60.85,12.35 N
M$3 N_EN \$2 VSS VSS N L=1.2U W=16U AS=40.29P AD=54.27P PS=25.1U PD=29.6U
* device instance $4 r0 *1 20.85,12.35 N
M$4 \$7 \$4 VSS VSS N L=1.2U W=12.6U AS=43.7025P AD=28.49P PS=26.45U PD=22.8U
* device instance $5 r0 *1 29.7,12.35 N
M$5 \$7 EN VSS VSS N L=1.2U W=12.6U AS=43.7025P AD=28.49P PS=26.45U PD=22.8U
* device instance $6 r0 *1 5.05,13.45 N
M$6 \$4 D VSS VSS N L=1.2U W=6.5U AS=33.625P AD=24.05P PS=21.65U PD=20.4U
* device instance $7 r0 *1 12.25,12.3 N
M$7 P_EN \$7 VSS VSS N L=1.2U W=12.5U AS=33.625P AD=28.12P PS=21.65U PD=22.6U
* device instance $8 r0 *1 38.3,12.25 N
M$8 \$8 EN VSS VSS N L=1.2U W=6.5U AS=24.375P AD=24.05P PS=20.5U PD=20.4U
* device instance $9 r0 *1 61.45,33.4 P
M$9 N_EN \$2 VDD VDD P L=1.5U W=24U AS=56.2075P AD=80.02P PS=33.2U PD=45U
* device instance $10 r0 *1 53.35,34 P
M$10 VDD \$8 \$2 VDD P L=1.5U W=20U AS=39.47P AD=56.2075P PS=24.3U PD=33.2U
* device instance $11 r0 *1 47.95,34.4 P
M$11 VDD \$4 \$2 VDD P L=1.5U W=20U AS=39.47P AD=74P PS=24.3U PD=47.4U
* device instance $12 r0 *1 37.15,35.65 P
M$12 \$8 EN VDD VDD P L=1.5U W=12.5U AS=41.62375P AD=46.25P PS=20.7U PD=32.4U
* device instance $13 r0 *1 26.5,36.425 P
M$13 \$12 \$4 \$7 VDD P L=1.5U W=15.05U AS=57.19P AD=15.05P PS=37.7U PD=17.05U
* device instance $14 r0 *1 30,36.425 P
M$14 VDD EN \$12 VDD P L=1.5U W=15.05U AS=15.05P AD=41.62375P PS=17.05U PD=20.7U
* device instance $15 r0 *1 13.3,34.4 P
M$15 P_EN \$7 VDD VDD P L=1.5U W=26.5U AS=69.49P AD=38.22P PS=40.85U PD=27.4U
* device instance $16 r0 *1 5.2,35 P
M$16 VDD D \$4 VDD P L=1.5U W=12.5U AS=46.25P AD=69.49P PS=32.4U PD=40.85U
.ENDS PDDR02

* cell OR7101
* pin IN5
* pin IN6
* pin IN7
* pin IN2
* pin IN1
* pin OUT1
* pin IN4
* pin IN3
* pin VDD
* pin VSS
.SUBCKT OR7101 IN5 IN6 IN7 IN2 IN1 OUT1 IN4 IN3 VDD VSS
* device instance $1 r0 *1 55.45,13.25 N
M$1 \$10 \$9 VSS VSS N L=1.2U W=6.5U AS=15.5P AD=24.05P PS=11.7U PD=20.4U
* device instance $2 r0 *1 60.85,12.75 N
M$2 OUT1 \$10 VSS VSS N L=1.2U W=7.5U AS=15.5P AD=27.75P PS=11.7U PD=22.4U
* device instance $3 r0 *1 41.15,10.75 N
M$3 \$14 \$7 VSS VSS N L=1.2U W=6.5U AS=16.925P AD=9.75P PS=12.9U PD=9.5U
* device instance $4 r0 *1 45.35,10.75 N
M$4 \$9 \$8 \$14 VSS N L=1.2U W=6.5U AS=9.75P AD=24.05P PS=9.5U PD=20.4U
* device instance $5 r0 *1 5.25,12 N
M$5 VSS IN5 \$7 VSS N L=1.2U W=9U AS=33.3P AD=17.55P PS=25.4U PD=12.9U
* device instance $6 r0 *1 10.35,12 N
M$6 \$7 IN6 VSS VSS N L=1.2U W=9U AS=17.55P AD=17.55P PS=12.9U PD=12.9U
* device instance $7 r0 *1 15.45,12 N
M$7 VSS IN7 \$7 VSS N L=1.2U W=9U AS=17.55P AD=17.55P PS=12.9U PD=12.9U
* device instance $8 r0 *1 20.55,12 N
M$8 \$8 IN4 VSS VSS N L=1.2U W=9U AS=17.55P AD=18.45P PS=12.9U PD=13.1U
* device instance $9 r0 *1 25.85,12 N
M$9 VSS IN3 \$8 VSS N L=1.2U W=9U AS=18.45P AD=17.55P PS=13.1U PD=12.9U
* device instance $10 r0 *1 30.95,12 N
M$10 \$8 IN2 VSS VSS N L=1.2U W=9U AS=17.55P AD=17.55P PS=12.9U PD=12.9U
* device instance $11 r0 *1 36.05,12 N
M$11 VSS IN1 \$8 VSS N L=1.2U W=9U AS=17.55P AD=16.925P PS=12.9U PD=12.9U
* device instance $12 r0 *1 49.7,35.95 P
M$12 \$9 \$8 VDD VDD P L=1.5U W=7.5U AS=39.93P AD=15P PS=22.5U PD=11.5U
* device instance $13 r0 *1 55.2,35.95 P
M$13 VDD \$7 \$9 VDD P L=1.5U W=7.5U AS=15P AD=40.135P PS=11.5U PD=24.6U
* device instance $14 r0 *1 41.55,36.3 P
M$14 VDD \$9 \$10 VDD P L=1.5U W=11.9U AS=24.79P AD=39.93P PS=20.8U PD=22.5U
* device instance $15 r0 *1 62.75,37.85 P
M$15 OUT1 \$10 VDD VDD P L=1.5U W=15U AS=40.135P AD=36.26P PS=24.6U PD=27U
* device instance $16 r0 *1 5.2,35.45 P
M$16 \$16 IN5 \$7 VDD P L=1.5U W=12.5U AS=46.25P AD=11.25P PS=32.4U PD=14.3U
* device instance $17 r0 *1 8.5,35.45 P
M$17 \$17 IN6 \$16 VDD P L=1.5U W=12.5U AS=11.25P AD=10.625P PS=14.3U PD=14.2U
* device instance $18 r0 *1 11.7,35.45 P
M$18 VDD IN7 \$17 VDD P L=1.5U W=12.5U AS=10.625P AD=65.1P PS=14.2U PD=25.7U
* device instance $19 r0 *1 20.4,38.45 P
M$19 \$19 IN4 VDD VDD P L=1.5U W=18.5U AS=65.1P AD=36.075P PS=25.7U PD=22.4U
* device instance $20 r0 *1 25.8,38.45 P
M$20 \$18 IN3 \$19 VDD P L=1.5U W=18.5U AS=36.075P AD=16.65P PS=22.4U PD=20.3U
* device instance $21 r0 *1 29.1,38.45 P
M$21 \$20 IN2 \$18 VDD P L=1.5U W=18.5U AS=16.65P AD=15.725P PS=20.3U PD=20.2U
* device instance $22 r0 *1 32.3,38.45 P
M$22 \$8 IN1 \$20 VDD P L=1.5U W=18.5U AS=15.725P AD=68.45P PS=20.2U PD=44.4U
.ENDS OR7101

* cell PDDR04
* pin EN
* pin D
* pin N_EN
* pin VDD
* pin VSS
.SUBCKT PDDR04 EN D N_EN VDD VSS
* device instance $1 r0 *1 48.7,12 N
M$1 \$10 \$4 \$7 VSS N L=1.2U W=10U AS=37P AD=11P PS=27.4U PD=12.2U
* device instance $2 r0 *1 52.1,12 N
M$2 \$10 \$9 VSS VSS N L=1.2U W=10U AS=34.135P AD=11P PS=21.3U PD=12.2U
* device instance $3 r0 *1 59.35,12.75 N
M$3 N_EN \$7 VSS VSS N L=1.2U W=12.2U AS=34.135P AD=27.01P PS=21.3U PD=22U
* device instance $4 r0 *1 5.05,13.45 N
M$4 \$4 D VSS VSS N L=1.2U W=6.5U AS=40.61P AD=24.05P PS=24.9U PD=20.4U
* device instance $5 r0 *1 12.725,11.35 N
M$5 P_EN \$2 VSS VSS N L=1.2U W=15.55U AS=40.61P AD=42.925P PS=24.9U PD=28.7U
* device instance $6 r0 *1 20.85,12.5 N
M$6 \$2 \$4 VSS VSS N L=1.2U W=12.1U AS=42.715P AD=26.64P PS=25.95U PD=21.8U
* device instance $7 r0 *1 29.7,12.5 N
M$7 \$2 EN VSS VSS N L=1.2U W=12.1U AS=42.715P AD=26.64P PS=25.95U PD=21.8U
* device instance $8 r0 *1 38.3,11.75 N
M$8 \$9 EN VSS VSS N L=1.2U W=6.5U AS=24.375P AD=24.05P PS=20.5U PD=20.4U
* device instance $9 r0 *1 60.7,33.55 P
M$9 N_EN \$7 VDD VDD P L=1.5U W=18U AS=44.67P AD=47.36P PS=27.2U PD=33U
* device instance $10 r0 *1 47.95,34.4 P
M$10 \$7 \$4 VDD VDD P L=1.5U W=16U AS=59.2P AD=31.2P PS=39.4U PD=19.9U
* device instance $11 r0 *1 53.35,34.4 P
M$11 VDD \$9 \$7 VDD P L=1.5U W=16U AS=31.2P AD=44.67P PS=19.9U PD=27.2U
* device instance $12 r0 *1 26.5,34.175 P
M$12 \$12 \$4 \$2 VDD P L=1.5U W=10.55U AS=40.09P AD=10.55P PS=28.7U PD=12.55U
* device instance $13 r0 *1 30,34.175 P
M$13 VDD EN \$12 VDD P L=1.5U W=10.55U AS=10.55P AD=35.63125P PS=12.55U
+ PD=18.65U
* device instance $14 r0 *1 37.15,35.65 P
M$14 \$9 EN VDD VDD P L=1.5U W=12.5U AS=35.63125P AD=46.25P PS=18.65U PD=32.4U
* device instance $15 r0 *1 14.95,34.4 P
M$15 P_EN \$2 VDD VDD P L=1.5U W=20U AS=47.835P AD=58.725P PS=29.15U PD=37U
* device instance $16 r0 *1 5.2,35 P
M$16 VDD D \$4 VDD P L=1.5U W=12.5U AS=46.25P AD=47.835P PS=32.4U PD=29.15U
.ENDS PDDR04

* cell AND501
* pin IN3
* pin IN2
* pin IN1
* pin IN5
* pin OUT1
* pin IN4
* pin VDD
* pin VSS
.SUBCKT AND501 IN3 IN2 IN1 IN5 OUT1 IN4 VDD VSS
* device instance $1 r0 *1 36.85,11.45 N
M$1 OUT1 \$6 VSS VSS N L=1.2U W=11U AS=40.7P AD=40.7P PS=29.4U PD=29.4U
* device instance $2 r0 *1 5.05,10 N
M$2 \$8 IN5 VSS VSS N L=1.2U W=13U AS=48.1P AD=13P PS=33.4U PD=15U
* device instance $3 r0 *1 8.25,10 N
M$3 \$9 IN4 \$8 VSS N L=1.2U W=13U AS=13P AD=13P PS=15U PD=15U
* device instance $4 r0 *1 11.45,10 N
M$4 \$10 IN3 \$9 VSS N L=1.2U W=13U AS=13P AD=13P PS=15U PD=15U
* device instance $5 r0 *1 14.65,10 N
M$5 \$11 IN2 \$10 VSS N L=1.2U W=13U AS=13P AD=22.065P PS=15U PD=19.9U
* device instance $6 r0 *1 19.7,11.85 N
M$6 \$6 IN1 \$11 VSS N L=1.2U W=13U AS=22.065P AD=29.97P PS=19.9U PD=23.6U
* device instance $7 r0 *1 5.2,35.7 P
M$7 VDD IN5 \$6 VDD P L=1.5U W=13U AS=48.1P AD=25.35P PS=33.4U PD=16.9U
* device instance $8 r0 *1 10.6,35.7 P
M$8 \$6 IN4 VDD VDD P L=1.5U W=13U AS=25.35P AD=25.35P PS=16.9U PD=16.9U
* device instance $9 r0 *1 16,35.7 P
M$9 VDD IN3 \$6 VDD P L=1.5U W=13U AS=25.35P AD=25.35P PS=16.9U PD=16.9U
* device instance $10 r0 *1 21.4,35.7 P
M$10 \$6 IN2 VDD VDD P L=1.5U W=13U AS=25.35P AD=29.25P PS=16.9U PD=17.5U
* device instance $11 r0 *1 27.4,35.7 P
M$11 \$6 IN1 VDD VDD P L=1.5U W=13U AS=61.8P AD=29.25P PS=29.5U PD=17.5U
* device instance $12 r0 *1 36.4,35.25 P
M$12 OUT1 \$6 VDD VDD P L=1.5U W=22U AS=61.8P AD=88P PS=29.5U PD=52U
.ENDS AND501

* cell OR3101
* pin IN3
* pin OUT1
* pin
* pin VDD
* pin IN2
* pin VSS
.SUBCKT OR3101 IN3 OUT1 \$4 VDD IN2 VSS
* device instance $1 r0 *1 5.05,13 N
M$1 VSS \$4 \$1 VSS N L=1.2U W=8U AS=29.6P AD=15.6P PS=23.4U PD=11.9U
* device instance $2 r0 *1 10.15,13 N
M$2 \$1 IN2 VSS VSS N L=1.2U W=8U AS=15.6P AD=15.6P PS=11.9U PD=11.9U
* device instance $3 r0 *1 15.25,13 N
M$3 \$1 IN3 VSS VSS N L=1.2U W=8U AS=41.965P AD=15.6P PS=23.05U PD=11.9U
* device instance $4 r0 *1 24.45,12.85 N
M$4 OUT1 \$1 VSS VSS N L=1.2U W=12U AS=41.965P AD=26.27P PS=23.05U PD=21.6U
* device instance $5 r0 *1 5.2,33.5 P
M$5 \$10 \$4 \$1 VDD P L=1.5U W=19U AS=70.3P AD=19P PS=45.4U PD=21U
* device instance $6 r0 *1 8.7,33.5 P
M$6 \$9 IN2 \$10 VDD P L=1.5U W=19U AS=19P AD=17.1P PS=21U PD=20.8U
* device instance $7 r0 *1 12,33.5 P
M$7 VDD IN3 \$9 VDD P L=1.5U W=19U AS=17.1P AD=79.3P PS=20.8U PD=27.4U
* device instance $8 r0 *1 21.9,34.5 P
M$8 OUT1 \$1 VDD VDD P L=1.5U W=17U AS=79.3P AD=62.9P PS=27.4U PD=41.4U
.ENDS OR3101

* cell XOR201
* pin IN2
* pin IN1
* pin OUT1
* pin VDD
* pin VSS
.SUBCKT XOR201 IN2 IN1 OUT1 VDD VSS
* device instance $1 r0 *1 31.55,11.25 N
M$1 VSS IN2 \$5 VSS N L=1.2U W=4.5U AS=16.65P AD=15.925P PS=16.4U PD=12.2U
* device instance $2 r0 *1 36.95,13 N
M$2 OUT1 \$6 VSS VSS N L=1.2U W=8U AS=15.925P AD=29.6P PS=12.2U PD=23.4U
* device instance $3 r0 *1 13.65,11 N
M$3 \$5 IN1 VSS VSS N L=1.2U W=4U AS=15.8P AD=15.8P PS=12.2U PD=12.2U
* device instance $4 r0 *1 5.05,13 N
M$4 \$8 IN2 \$4 VSS N L=1.2U W=8U AS=29.6P AD=8P PS=23.4U PD=10U
* device instance $5 r0 *1 8.25,13 N
M$5 VSS IN1 \$8 VSS N L=1.2U W=8U AS=8P AD=15.8P PS=10U PD=12.2U
* device instance $6 r0 *1 19.05,13 N
M$6 \$6 \$4 \$5 VSS N L=1.2U W=8U AS=15.8P AD=29.6P PS=12.2U PD=23.4U
* device instance $7 r0 *1 5.2,34.6 P
M$7 \$4 IN2 VDD VDD P L=1.5U W=8U AS=29.6P AD=15.6P PS=23.4U PD=11.9U
* device instance $8 r0 *1 10.6,34.6 P
M$8 VDD IN1 \$4 VDD P L=1.5U W=8U AS=15.6P AD=25.125P PS=11.9U PD=16.7U
* device instance $9 r0 *1 33.75,34.25 P
M$9 OUT1 \$6 VDD VDD P L=1.5U W=18U AS=46.215P AD=47.36P PS=27.5U PD=33U
* device instance $10 r0 *1 16.3,36.85 P
M$10 \$6 \$4 VDD VDD P L=1.5U W=12.5U AS=25.125P AD=26.25P PS=16.7U PD=16.7U
* device instance $11 r0 *1 22,36.85 P
M$11 \$10 IN1 \$6 VDD P L=1.5U W=12.5U AS=26.25P AD=10.625P PS=16.7U PD=14.2U
* device instance $12 r0 *1 25.2,36.85 P
M$12 \$10 IN2 VDD VDD P L=1.5U W=12.5U AS=46.215P AD=10.625P PS=27.5U PD=14.2U
.ENDS XOR201

* cell AND401
* pin IN4
* pin IN3
* pin IN2
* pin IN1
* pin OUT1
* pin VDD
* pin VSS
.SUBCKT AND401 IN4 IN3 IN2 IN1 OUT1 VDD VSS
* device instance $1 r0 *1 32.65,11.5 N
M$1 OUT1 \$6 VSS VSS N L=1.2U W=10U AS=37P AD=37P PS=27.4U PD=27.4U
* device instance $2 r0 *1 5.55,10.5 N
M$2 \$9 IN4 VSS VSS N L=1.2U W=12U AS=44.4P AD=12P PS=31.4U PD=14U
* device instance $3 r0 *1 8.75,10.5 N
M$3 \$8 IN3 \$9 VSS N L=1.2U W=12U AS=12P AD=16.2P PS=14U PD=14.7U
* device instance $4 r0 *1 12.65,10.5 N
M$4 \$10 IN2 \$8 VSS N L=1.2U W=12U AS=16.2P AD=16.2P PS=14.7U PD=14.7U
* device instance $5 r0 *1 16.55,10.5 N
M$5 \$6 IN1 \$10 VSS N L=1.2U W=12U AS=16.2P AD=44.4P PS=14.7U PD=31.4U
* device instance $6 r0 *1 5.2,35.95 P
M$6 \$6 IN4 VDD VDD P L=1.5U W=12U AS=44.4P AD=23.4P PS=31.4U PD=15.9U
* device instance $7 r0 *1 10.6,35.95 P
M$7 VDD IN3 \$6 VDD P L=1.5U W=12U AS=23.4P AD=23.4P PS=15.9U PD=15.9U
* device instance $8 r0 *1 16,35.95 P
M$8 \$6 IN2 VDD VDD P L=1.5U W=12U AS=23.4P AD=23.4P PS=15.9U PD=15.9U
* device instance $9 r0 *1 21.4,35.95 P
M$9 VDD IN1 \$6 VDD P L=1.5U W=12U AS=23.4P AD=44.4P PS=15.9U PD=31.4U
* device instance $10 r0 *1 32.5,34.5 P
M$10 OUT1 \$6 VDD VDD P L=1.5U W=19U AS=70.3P AD=70.3P PS=45.4U PD=45.4U
.ENDS AND401

* cell DEC24H
* pin EN
* pin A1
* pin A2
* pin Q4
* pin VDD
* pin VSS
.SUBCKT DEC24H EN A1 A2 Q4 VDD VSS
* device instance $1 r0 *1 122.25,11.65 N
M$1 Q4 \$14 VSS VSS N L=1.2U W=8U AS=24.86P AD=14.99P PS=17.4U PD=15.8U
* device instance $2 r0 *1 109.45,10.95 N
M$2 \$20 A2 \$14 VSS N L=1.2U W=8U AS=29.6P AD=8P PS=23.4U PD=10U
* device instance $3 r0 *1 112.65,10.95 N
M$3 \$19 A1 \$20 VSS N L=1.2U W=8U AS=8P AD=8P PS=10U PD=10U
* device instance $4 r0 *1 115.85,10.95 N
M$4 \$19 EN VSS VSS N L=1.2U W=8U AS=24.86P AD=8P PS=17.4U PD=10U
* device instance $5 r0 *1 95.075,11.65 N
M$5 Q3 \$11 VSS VSS N L=1.2U W=8.05U AS=24.62125P AD=15.015P PS=17.5U PD=15.8U
* device instance $6 r0 *1 80.15,10.95 N
M$6 \$21 A2 \$11 VSS N L=1.2U W=8U AS=29.6P AD=8P PS=23.4U PD=10U
* device instance $7 r0 *1 83.35,10.95 N
M$7 \$22 \$5 \$21 VSS N L=1.2U W=8U AS=8P AD=16.4P PS=10U PD=12.1U
* device instance $8 r0 *1 88.65,10.95 N
M$8 \$22 EN VSS VSS N L=1.2U W=8U AS=24.62125P AD=16.4P PS=17.5U PD=12.1U
* device instance $9 r0 *1 30.925,11.65 N
M$9 Q1 \$9 VSS VSS N L=1.2U W=8.05U AS=25.12P AD=15.2P PS=17.75U PD=15.9U
* device instance $10 r0 *1 37.35,10.95 N
M$10 \$17 EN VSS VSS N L=1.2U W=8U AS=25.12P AD=16.4P PS=17.75U PD=12.1U
* device instance $11 r0 *1 42.65,10.95 N
M$11 \$18 \$5 \$17 VSS N L=1.2U W=8U AS=16.4P AD=7.2P PS=12.1U PD=9.8U
* device instance $12 r0 *1 45.65,10.95 N
M$12 \$9 \$4 \$18 VSS N L=1.2U W=8U AS=7.2P AD=29.6P PS=9.8U PD=23.4U
* device instance $13 r0 *1 3.75,11.65 N
M$13 Q2 \$7 VSS VSS N L=1.2U W=8U AS=25.73P AD=14.99P PS=18.4U PD=15.8U
* device instance $14 r0 *1 10.15,10.95 N
M$14 \$16 EN VSS VSS N L=1.2U W=8U AS=25.73P AD=8P PS=18.4U PD=10U
* device instance $15 r0 *1 13.35,10.95 N
M$15 \$15 A1 \$16 VSS N L=1.2U W=8U AS=8P AD=8P PS=10U PD=10U
* device instance $16 r0 *1 16.55,10.95 N
M$16 \$7 \$4 \$15 VSS N L=1.2U W=8U AS=8P AD=29.6P PS=10U PD=23.4U
* device instance $17 r0 *1 70.55,9.3 N
M$17 \$5 A1 VSS VSS N L=1.2U W=7U AS=25.9P AD=29.4P PS=21.4U PD=22.4U
* device instance $18 r0 *1 55.2,9.3 N
M$18 \$4 A2 VSS VSS N L=1.2U W=7U AS=25.9P AD=25.9P PS=21.4U PD=21.4U
* device instance $19 r0 *1 104.3,36.3 P
M$19 VDD A2 \$14 VDD P L=1.5U W=10U AS=37P AD=19.5P PS=27.4U PD=13.9U
* device instance $20 r0 *1 109.7,36.3 P
M$20 \$14 A1 VDD VDD P L=1.5U W=10U AS=19.5P AD=19.5P PS=13.9U PD=13.9U
* device instance $21 r0 *1 115.1,36.3 P
M$21 \$14 EN VDD VDD P L=1.5U W=10U AS=41.72P AD=19.5P PS=25.4U PD=13.9U
* device instance $22 r0 *1 122.1,35.6 P
M$22 Q4 \$14 VDD VDD P L=1.5U W=16U AS=41.72P AD=42.765P PS=25.4U PD=31.2U
* device instance $23 r0 *1 58.15,35.8 P
M$23 VDD A2 \$4 VDD P L=1.5U W=17.6U AS=50.04P AD=54.96P PS=32.2U PD=32.55U
* device instance $24 r0 *1 68.2,35.8 P
M$24 \$5 A1 VDD VDD P L=1.5U W=17U AS=54.96P AD=48.16P PS=32.55U PD=31U
* device instance $25 r0 *1 10.9,36.3 P
M$25 \$7 EN VDD VDD P L=1.5U W=10U AS=41.72P AD=19.5P PS=25.4U PD=13.9U
* device instance $26 r0 *1 16.3,36.3 P
M$26 VDD A1 \$7 VDD P L=1.5U W=10U AS=19.5P AD=19.5P PS=13.9U PD=13.9U
* device instance $27 r0 *1 21.7,36.3 P
M$27 \$7 \$4 VDD VDD P L=1.5U W=10U AS=19.5P AD=37P PS=13.9U PD=27.4U
* device instance $28 r0 *1 3.9,35.6 P
M$28 VDD \$7 Q2 VDD P L=1.5U W=16U AS=42.765P AD=41.72P PS=31.2U PD=25.4U
* device instance $29 r0 *1 77.4,36.65 P
M$29 VDD A2 \$11 VDD P L=1.5U W=10.2U AS=37.74P AD=18.7227P PS=27.8U PD=13.8775U
* device instance $30 r0 *1 82.45,36.75 P
M$30 \$11 \$5 VDD VDD P L=1.50092637738U W=10.255U AS=18.7227P AD=20.3463P
+ PS=13.8775U PD=14.3775U
* device instance $31 r0 *1 88.2,36.75 P
M$31 \$11 EN VDD VDD P L=1.5U W=10U AS=41.165P AD=20.3463P PS=25.1U PD=14.3775U
* device instance $32 r0 *1 95.75,37.3 P
M$32 Q3 \$11 VDD VDD P L=1.5U W=15.7U AS=41.165P AD=38.85P PS=25.1U PD=28.4U
* device instance $33 r0 *1 37.8,36.75 P
M$33 \$9 EN VDD VDD P L=1.5U W=10U AS=41.165P AD=20.3512P PS=25.1U PD=14.3775U
* device instance $34 r0 *1 43.55,36.75 P
M$34 \$9 \$5 VDD VDD P L=1.50031204291U W=10.255U AS=18.6547P AD=20.3512P
+ PS=13.8275U PD=14.3775U
* device instance $35 r0 *1 48.6,36.675 P
M$35 \$9 \$4 VDD VDD P L=1.5U W=10.15U AS=18.6547P AD=37.555P PS=13.8275U
+ PD=27.7U
* device instance $36 r0 *1 30.25,37.3 P
M$36 VDD \$9 Q1 VDD P L=1.5U W=15.7U AS=38.85P AD=41.165P PS=28.4U PD=25.1U
.ENDS DEC24H

* cell NOR401
* pin IN2
* pin IN4
* pin IN1
* pin OUT1
* pin IN3
* pin VDD
* pin VSS
.SUBCKT NOR401 IN2 IN4 IN1 OUT1 IN3 VDD VSS
* device instance $1 r0 *1 5.15,11.5 N
M$1 VSS IN1 \$5 VSS N L=1.2U W=5U AS=18.5P AD=9.75P PS=17.4U PD=8.9U
* device instance $2 r0 *1 10.25,11.5 N
M$2 \$5 IN2 VSS VSS N L=1.2U W=5U AS=9.75P AD=9.75P PS=8.9U PD=8.9U
* device instance $3 r0 *1 15.35,11.5 N
M$3 VSS IN3 \$5 VSS N L=1.2U W=5U AS=9.75P AD=9.75P PS=8.9U PD=8.9U
* device instance $4 r0 *1 20.45,11.5 N
M$4 \$5 IN4 VSS VSS N L=1.2U W=5U AS=9.75P AD=18.5P PS=8.9U PD=17.4U
* device instance $5 r0 *1 34.55,13 N
M$5 VSS \$5 \$6 VSS N L=1.2U W=8U AS=31.2P AD=15.6P PS=23.8U PD=11.9U
* device instance $6 r0 *1 39.65,13 N
M$6 OUT1 \$6 VSS VSS N L=1.2U W=8U AS=15.6P AD=29.6P PS=11.9U PD=23.4U
* device instance $7 r0 *1 19.2,36.75 P
M$7 \$12 IN3 \$9 VDD P L=1.5U W=16U AS=59.2P AD=16P PS=39.4U PD=18U
* device instance $8 r0 *1 22.7,36.75 P
M$8 \$5 IN4 \$12 VDD P L=1.5U W=16U AS=16P AD=59.2P PS=18U PD=39.4U
* device instance $9 r0 *1 5.3,36.75 P
M$9 \$11 IN1 VDD VDD P L=1.5U W=16U AS=59.2P AD=16P PS=39.4U PD=18U
* device instance $10 r0 *1 8.8,36.75 P
M$10 \$9 IN2 \$11 VDD P L=1.5U W=16U AS=16P AD=59.2P PS=18U PD=39.4U
* device instance $11 r0 *1 34,33.75 P
M$11 VDD \$5 \$6 VDD P L=1.5U W=10U AS=37P AD=29.8P PS=27.4U PD=18.4U
* device instance $12 r0 *1 39.9,35.75 P
M$12 OUT1 \$6 VDD VDD P L=1.5U W=14U AS=29.8P AD=51.8P PS=18.4U PD=35.4U
.ENDS NOR401

* cell NND301
* pin OUT1
* pin VDD
* pin IN3
* pin IN2
* pin IN1
* pin VSS
.SUBCKT NND301 OUT1 VDD IN3 IN2 IN1 VSS
* device instance $1 r0 *1 27.25,13 N
M$1 VSS \$5 \$8 VSS N L=1.2U W=7U AS=28P AD=14.7P PS=22U PD=11.2U
* device instance $2 r0 *1 32.65,13 N
M$2 OUT1 \$8 VSS VSS N L=1.2U W=7U AS=14.7P AD=25.9P PS=11.2U PD=21.4U
* device instance $3 r0 *1 10.05,12.5 N
M$3 \$10 IN3 VSS VSS N L=1.2U W=8U AS=29.6P AD=7.2P PS=23.4U PD=9.8U
* device instance $4 r0 *1 13.05,12.5 N
M$4 \$9 IN2 \$10 VSS N L=1.2U W=8U AS=7.2P AD=10P PS=9.8U PD=10.5U
* device instance $5 r0 *1 16.75,12.5 N
M$5 \$5 IN1 \$9 VSS N L=1.2U W=8U AS=10P AD=29.6P PS=10.5U PD=23.4U
* device instance $6 r0 *1 27.1,34.2 P
M$6 VDD \$5 \$8 VDD P L=1.5U W=16U AS=59.2P AD=31.2P PS=39.4U PD=19.9U
* device instance $7 r0 *1 32.5,34.2 P
M$7 OUT1 \$8 VDD VDD P L=1.5U W=16U AS=31.2P AD=59.2P PS=19.9U PD=39.4U
* device instance $8 r0 *1 5.2,36.2 P
M$8 \$5 IN3 VDD VDD P L=1.5U W=8U AS=29.6P AD=15.6P PS=23.4U PD=11.9U
* device instance $9 r0 *1 10.6,36.2 P
M$9 VDD IN2 \$5 VDD P L=1.5U W=8U AS=15.6P AD=15.6P PS=11.9U PD=11.9U
* device instance $10 r0 *1 16,36.2 P
M$10 \$5 IN1 VDD VDD P L=1.5U W=8U AS=15.6P AD=29.6P PS=11.9U PD=23.4U
.ENDS NND301

* cell NND401
* pin IN4
* pin IN2
* pin IN1
* pin OUT1
* pin IN3
* pin VDD
* pin VSS
.SUBCKT NND401 IN4 IN2 IN1 OUT1 IN3 VDD VSS
* device instance $1 r0 *1 5.05,11.95 N
M$1 \$11 IN4 VSS VSS N L=1.2U W=10U AS=37P AD=13P PS=27.4U PD=12.6U
* device instance $2 r0 *1 8.85,11.95 N
M$2 \$10 IN3 \$11 VSS N L=1.2U W=10U AS=13P AD=10.5P PS=12.6U PD=12.1U
* device instance $3 r0 *1 12.15,11.95 N
M$3 \$12 IN2 \$10 VSS N L=1.2U W=10U AS=10.5P AD=19.5P PS=12.1U PD=13.9U
* device instance $4 r0 *1 17.25,11.95 N
M$4 \$5 IN1 \$12 VSS N L=1.2U W=10U AS=19.5P AD=37P PS=13.9U PD=27.4U
* device instance $5 r0 *1 35.65,13 N
M$5 VSS \$5 \$6 VSS N L=1.2U W=7U AS=28P AD=14.7P PS=22U PD=11.2U
* device instance $6 r0 *1 41.05,13 N
M$6 OUT1 \$6 VSS VSS N L=1.2U W=7U AS=14.7P AD=25.9P PS=11.2U PD=21.4U
* device instance $7 r0 *1 35.5,33.95 P
M$7 VDD \$5 \$6 VDD P L=1.5U W=15.5U AS=57.35P AD=30.225P PS=38.4U PD=19.4U
* device instance $8 r0 *1 40.9,33.95 P
M$8 OUT1 \$6 VDD VDD P L=1.5U W=15.5U AS=30.225P AD=57.35P PS=19.4U PD=38.4U
* device instance $9 r0 *1 5.4,34.2 P
M$9 \$5 IN4 VDD VDD P L=1.5U W=10U AS=37P AD=19.5P PS=27.4U PD=13.9U
* device instance $10 r0 *1 10.8,34.2 P
M$10 VDD IN3 \$5 VDD P L=1.5U W=10U AS=19.5P AD=19.5P PS=13.9U PD=13.9U
* device instance $11 r0 *1 16.2,34.2 P
M$11 \$5 IN2 VDD VDD P L=1.5U W=10U AS=19.5P AD=19.5P PS=13.9U PD=13.9U
* device instance $12 r0 *1 21.6,34.2 P
M$12 VDD IN1 \$5 VDD P L=1.5U W=10U AS=19.5P AD=37P PS=13.9U PD=27.4U
.ENDS NND401

* cell NND501
* pin IN3
* pin IN2
* pin IN1
* pin OUT1
* pin IN5
* pin IN4
* pin VDD
* pin VSS
.SUBCKT NND501 IN3 IN2 IN1 OUT1 IN5 IN4 VDD VSS
* device instance $1 r0 *1 5.05,11.95 N
M$1 \$8 IN5 VSS VSS N L=1.2U W=10U AS=37P AD=13P PS=27.4U PD=12.6U
* device instance $2 r0 *1 8.85,11.95 N
M$2 \$9 IN4 \$8 VSS N L=1.2U W=10U AS=13P AD=10.5P PS=12.6U PD=12.1U
* device instance $3 r0 *1 12.15,11.95 N
M$3 \$10 IN3 \$9 VSS N L=1.2U W=10U AS=10.5P AD=22.5P PS=12.1U PD=14.5U
* device instance $4 r0 *1 17.85,11.95 N
M$4 \$11 IN2 \$10 VSS N L=1.2U W=10U AS=22.5P AD=15P PS=14.5U PD=13U
* device instance $5 r0 *1 22.05,11.95 N
M$5 \$5 IN1 \$11 VSS N L=1.2U W=10U AS=15P AD=37P PS=13U PD=27.4U
* device instance $6 r0 *1 39.25,13.25 N
M$6 \$6 \$5 VSS VSS N L=1.2U W=6.5U AS=18.6P AD=26P PS=12.8U PD=21U
* device instance $7 r0 *1 45.25,12.5 N
M$7 OUT1 \$6 VSS VSS N L=1.2U W=8U AS=18.6P AD=29.6P PS=12.8U PD=23.4U
* device instance $8 r0 *1 39.1,32.45 P
M$8 VDD \$5 \$6 VDD P L=1.5U W=12.5U AS=46.25P AD=31.125P PS=32.4U PD=18.5U
* device instance $9 r0 *1 45.1,33.2 P
M$9 OUT1 \$6 VDD VDD P L=1.5U W=14U AS=31.125P AD=51.8P PS=18.5U PD=35.4U
* device instance $10 r0 *1 5.4,34.2 P
M$10 \$5 IN5 VDD VDD P L=1.5U W=10U AS=37P AD=19.5P PS=27.4U PD=13.9U
* device instance $11 r0 *1 10.8,34.2 P
M$11 VDD IN4 \$5 VDD P L=1.5U W=10U AS=19.5P AD=19.5P PS=13.9U PD=13.9U
* device instance $12 r0 *1 16.2,34.2 P
M$12 \$5 IN3 VDD VDD P L=1.5U W=10U AS=19.5P AD=19.5P PS=13.9U PD=13.9U
* device instance $13 r0 *1 21.6,34.2 P
M$13 VDD IN2 \$5 VDD P L=1.5U W=10U AS=19.5P AD=19.5P PS=13.9U PD=13.9U
* device instance $14 r0 *1 27,34.2 P
M$14 \$5 IN1 VDD VDD P L=1.5U W=10U AS=19.5P AD=37P PS=13.9U PD=27.4U
.ENDS NND501

* cell DFPR11
* pin C
* pin D
* pin PRB
* pin QB
* pin Q
* pin VDD
* pin VSS
.SUBCKT DFPR11 C D PRB QB Q VDD VSS
* device instance $1 r0 *1 75.85,12.025 N
M$1 \$16 \$11 VSS VSS N L=1.2U W=9.95U AS=36.815P AD=9.95P PS=27.3U PD=11.95U
* device instance $2 r0 *1 79.05,12.025 N
M$2 \$3 PRB \$16 VSS N L=1.2U W=9.95U AS=9.95P AD=36.815P PS=11.95U PD=27.3U
* device instance $3 r0 *1 64.65,10.65 N
M$3 VSS \$3 \$12 VSS N L=1.2U W=5U AS=16.05P AD=18.5P PS=12.2U PD=17.4U
* device instance $4 r0 *1 35.25,11.15 N
M$4 \$15 PRB \$9 VSS N L=1.2U W=6U AS=16.3P AD=11.7P PS=12.2U PD=9.9U
* device instance $5 r0 *1 40.35,11.15 N
M$5 VSS \$2 \$15 VSS N L=1.2U W=6U AS=11.7P AD=11.7P PS=9.9U PD=9.9U
* device instance $6 r0 *1 45.45,11.15 N
M$6 \$2 \$8 VSS VSS N L=1.2U W=6U AS=11.7P AD=16.3P PS=9.9U PD=12.2U
* device instance $7 r0 *1 24.75,12.15 N
M$7 \$8 \$4 D VSS N L=1.2U W=8U AS=29.6P AD=15.6P PS=23.4U PD=11.9U
* device instance $8 r0 *1 29.85,12.15 N
M$8 \$9 \$6 \$8 VSS N L=1.2U W=8U AS=15.6P AD=16.3P PS=11.9U PD=12.2U
* device instance $9 r0 *1 50.85,12.15 N
M$9 \$11 \$6 \$2 VSS N L=1.2U W=8U AS=16.3P AD=28.8P PS=12.2U PD=15.2U
* device instance $10 r0 *1 59.25,12.15 N
M$10 \$12 \$4 \$11 VSS N L=1.2U W=8U AS=28.8P AD=16.05P PS=15.2U PD=12.2U
* device instance $11 r0 *1 89.15,12.15 N
M$11 VSS \$3 QB VSS N L=1.2U W=8U AS=29.6P AD=15.6P PS=23.4U PD=11.9U
* device instance $12 r0 *1 94.25,12.15 N
M$12 Q QB VSS VSS N L=1.2U W=8U AS=15.6P AD=33.225P PS=11.9U PD=24.7U
* device instance $13 r0 *1 7.05,12.575 N
M$13 VSS C \$4 VSS N L=1.2U W=7.85U AS=29.045P AD=15.3075P PS=23.1U PD=11.75U
* device instance $14 r0 *1 12.15,12.575 N
M$14 \$6 \$4 VSS VSS N L=1.2U W=7.85U AS=15.3075P AD=30.615P PS=11.75U PD=23.5U
* device instance $15 r0 *1 57.5,33.2 P
M$15 \$11 \$4 \$2 VDD P L=1.5U W=8U AS=24.57P AD=15.6P PS=16.4U PD=11.9U
* device instance $16 r0 *1 62.9,33.2 P
M$16 \$12 \$6 \$11 VDD P L=1.5U W=8U AS=15.6P AD=15.6P PS=11.9U PD=11.9U
* device instance $17 r0 *1 68.3,33.2 P
M$17 VDD \$3 \$12 VDD P L=1.5U W=8U AS=15.6P AD=25.885P PS=11.9U PD=17.95U
* device instance $18 r0 *1 51.8,35.3 P
M$18 \$2 \$8 VDD VDD P L=1.5U W=12.2U AS=45.75P AD=24.57P PS=31.9U PD=16.4U
* device instance $19 r0 *1 73.7,36.225 P
M$19 \$3 \$11 VDD VDD P L=1.5U W=14.05U AS=25.885P AD=27.3975P PS=17.95U
+ PD=17.95U
* device instance $20 r0 *1 79.1,36.225 P
M$20 VDD PRB \$3 VDD P L=1.5U W=14.05U AS=27.3975P AD=51.985P PS=17.95U PD=35.5U
* device instance $21 r0 *1 24.6,35.3 P
M$21 \$8 \$6 D VDD P L=1.5U W=8U AS=29.6P AD=15.6P PS=23.4U PD=11.9U
* device instance $22 r0 *1 30,35.3 P
M$22 \$9 \$4 \$8 VDD P L=1.5U W=8U AS=15.6P AD=15.975P PS=11.9U PD=12.2U
* device instance $23 r0 *1 35.7,36.8 P
M$23 VDD PRB \$9 VDD P L=1.5U W=5U AS=15.975P AD=9.75P PS=12.2U PD=8.9U
* device instance $24 r0 *1 41.1,36.8 P
M$24 \$9 \$2 VDD VDD P L=1.5U W=5U AS=9.75P AD=18.5P PS=8.9U PD=17.4U
* device instance $25 r0 *1 87.85,33.05 P
M$25 VDD \$3 QB VDD P L=1.5U W=20U AS=54.76P AD=48.08375P PS=37U PD=29.1U
* device instance $26 r0 *1 95.1,33.925 P
M$26 Q QB VDD VDD P L=1.5U W=18.05U AS=48.08375P AD=66.785P PS=29.1U PD=43.5U
* device instance $27 r0 *1 12,32.7 P
M$27 \$6 \$4 VDD VDD P L=1.5U W=14U AS=31.25P AD=54.6P PS=19.2U PD=35.8U
* device instance $28 r0 *1 6.3,33.2 P
M$28 VDD C \$4 VDD P L=1.5U W=15U AS=55.5P AD=31.25P PS=37.4U PD=19.2U
.ENDS DFPR11

* cell NOR301
* pin IN2
* pin OUT1
* pin VDD
* pin IN3
* pin IN1
* pin VSS
.SUBCKT NOR301 IN2 OUT1 VDD IN3 IN1 VSS
* device instance $1 r0 *1 27.2,11.5 N
M$1 VSS \$5 \$4 VSS N L=1.2U W=4U AS=14.8P AD=14.05P PS=15.4U PD=11.25U
* device instance $2 r0 *1 32.65,13 N
M$2 OUT1 \$4 VSS VSS N L=1.2U W=7U AS=14.05P AD=25.9P PS=11.25U PD=21.4U
* device instance $3 r0 *1 5.15,11 N
M$3 \$5 IN1 VSS VSS N L=1.2U W=6U AS=22.2P AD=11.7P PS=19.4U PD=9.9U
* device instance $4 r0 *1 10.25,11 N
M$4 VSS IN2 \$5 VSS N L=1.2U W=6U AS=11.7P AD=11.7P PS=9.9U PD=9.9U
* device instance $5 r0 *1 15.35,11 N
M$5 \$5 IN3 VSS VSS N L=1.2U W=6U AS=11.7P AD=22.2P PS=9.9U PD=19.4U
* device instance $6 r0 *1 5.3,34.2 P
M$6 \$10 IN1 VDD VDD P L=1.5U W=16U AS=59.2P AD=12.8P PS=39.4U PD=17.6U
* device instance $7 r0 *1 8.4,34.2 P
M$7 \$9 IN2 \$10 VDD P L=1.5U W=16U AS=12.8P AD=12.8P PS=17.6U PD=17.6U
* device instance $8 r0 *1 11.5,34.2 P
M$8 \$5 IN3 \$9 VDD P L=1.5U W=16U AS=12.8P AD=72P PS=17.6U PD=41U
* device instance $9 r0 *1 26.8,35.7 P
M$9 \$4 \$5 VDD VDD P L=1.5U W=7U AS=27.65P AD=25.9P PS=18.2U PD=21.4U
* device instance $10 r0 *1 32.5,32.2 P
M$10 OUT1 \$4 VDD VDD P L=1.5U W=14U AS=27.65P AD=51.8P PS=18.2U PD=35.4U
.ENDS NOR301

* cell NND300
* pin VDD
* pin IN3
* pin OUT1
* pin IN2
* pin IN1
* pin VSS
.SUBCKT NND300 VDD IN3 OUT1 IN2 IN1 VSS
* device instance $1 r0 *1 10.05,8.75 N
M$1 \$8 IN3 VSS VSS N L=1.2U W=15.5U AS=57.35P AD=17.05P PS=38.4U PD=17.7U
* device instance $2 r0 *1 13.45,8.75 N
M$2 \$7 IN2 \$8 VSS N L=1.2U W=15.5U AS=17.05P AD=16.275P PS=17.7U PD=17.6U
* device instance $3 r0 *1 16.75,8.75 N
M$3 OUT1 IN1 \$7 VSS N L=1.2U W=15.5U AS=16.275P AD=57.35P PS=17.6U PD=38.4U
* device instance $4 r0 *1 5.5,33.95 P
M$4 OUT1 IN3 VDD VDD P L=1.5U W=15.5U AS=57.35P AD=30.225P PS=38.4U PD=19.4U
* device instance $5 r0 *1 10.9,33.95 P
M$5 VDD IN2 OUT1 VDD P L=1.5U W=15.5U AS=30.225P AD=30.225P PS=19.4U PD=19.4U
* device instance $6 r0 *1 16.3,33.95 P
M$6 OUT1 IN1 VDD VDD P L=1.5U W=15.5U AS=30.225P AD=57.35P PS=19.4U PD=38.4U
.ENDS NND300

* cell NOR201
* pin OUT1
* pin VDD
* pin IN1
* pin IN2
* pin VSS
.SUBCKT NOR201 OUT1 VDD IN1 IN2 VSS
* device instance $1 r0 *1 21.45,14.45 N
M$1 \$2 \$7 VSS VSS N L=1.2U W=5U AS=18.21875P AD=18.75P PS=13.15U PD=17.5U
* device instance $2 r0 *1 27.05,12.575 N
M$2 OUT1 \$2 VSS VSS N L=1.2U W=8.75U AS=18.21875P AD=32.375P PS=13.15U PD=24.9U
* device instance $3 r0 *1 6,11.925 N
M$3 VSS IN1 \$7 VSS N L=1.2U W=4.95U AS=18.315P AD=9.6525P PS=17.3U PD=8.85U
* device instance $4 r0 *1 11.1,11.925 N
M$4 \$7 IN2 VSS VSS N L=1.2U W=4.95U AS=9.6525P AD=18.315P PS=8.85U PD=17.3U
* device instance $5 r0 *1 6.3,33 P
M$5 \$8 IN1 VDD VDD P L=1.5U W=15U AS=55.5P AD=15P PS=37.4U PD=17U
* device instance $6 r0 *1 9.8,33 P
M$6 \$7 IN2 \$8 VDD P L=1.5U W=15U AS=15P AD=55.5P PS=17U PD=37.4U
* device instance $7 r0 *1 21.1,29.4 P
M$7 VDD \$7 \$2 VDD P L=1.5U W=10U AS=37P AD=30.16P PS=27.4U PD=19.3U
* device instance $8 r0 *1 26.8,32.5 P
M$8 OUT1 \$2 VDD VDD P L=1.5U W=14U AS=30.16P AD=54.6P PS=19.3U PD=35.8U
.ENDS NOR201

* cell AND301
* pin OUT1
* pin VDD
* pin IN3
* pin IN2
* pin IN1
* pin VSS
.SUBCKT AND301 OUT1 VDD IN3 IN2 IN1 VSS
* device instance $1 r0 *1 28.55,12.9 N
M$1 OUT1 \$2 VSS VSS N L=1.2U W=8U AS=29.6P AD=29.6P PS=23.4U PD=23.4U
* device instance $2 r0 *1 5.05,11.5 N
M$2 \$9 IN3 VSS VSS N L=1.2U W=10U AS=37P AD=10P PS=27.4U PD=12U
* device instance $3 r0 *1 8.25,11.5 N
M$3 \$8 IN2 \$9 VSS N L=1.2U W=10U AS=10P AD=10P PS=12U PD=12U
* device instance $4 r0 *1 11.45,11.5 N
M$4 \$2 IN1 \$8 VSS N L=1.2U W=10U AS=10P AD=37P PS=12U PD=27.4U
* device instance $5 r0 *1 5.2,35.2 P
M$5 \$2 IN3 VDD VDD P L=1.5U W=13U AS=48.1P AD=25.35P PS=33.4U PD=16.9U
* device instance $6 r0 *1 10.6,35.2 P
M$6 VDD IN2 \$2 VDD P L=1.5U W=13U AS=25.35P AD=25.35P PS=16.9U PD=16.9U
* device instance $7 r0 *1 16,35.2 P
M$7 \$2 IN1 VDD VDD P L=1.5U W=13U AS=25.35P AD=48.1P PS=16.9U PD=33.4U
* device instance $8 r0 *1 28.4,35.5 P
M$8 OUT1 \$2 VDD VDD P L=1.5U W=17U AS=62.9P AD=62.9P PS=41.4U PD=41.4U
.ENDS AND301

* cell ADNR01
* pin OUT1
* pin VDD
* pin C
* pin A
* pin B
* pin VSS
.SUBCKT ADNR01 OUT1 VDD C A B VSS
* device instance $1 r0 *1 6.45,9.25 N
M$1 \$8 B VSS VSS N L=1.2U W=15.5U AS=57.35P AD=34P PS=38.4U PD=20U
* device instance $2 r0 *1 12.15,11 N
M$2 OUT1 A \$8 VSS N L=1.2U W=12U AS=34P AD=22.9P PS=20U PD=15.9U
* device instance $3 r0 *1 17.25,12 N
M$3 VSS C OUT1 VSS N L=1.2U W=10U AS=22.9P AD=37P PS=15.9U PD=27.4U
* device instance $4 r0 *1 19.4,33.5 P
M$4 OUT1 C \$1 VDD P L=1.5U W=19U AS=56.575P AD=70.3P PS=25.4U PD=45.4U
* device instance $5 r0 *1 4.45,34.725 P
M$5 VDD B \$1 VDD P L=1.5U W=24.25U AS=70.485P AD=68.87P PS=45.5U PD=38.15U
* device instance $6 r0 *1 13.5,34.725 P
M$6 VDD A \$1 VDD P L=1.5U W=23.55U AS=56.575P AD=68.87P PS=25.4U PD=38.15U
.ENDS ADNR01

* cell NND201
* pin OUT1
* pin IN1
* pin IN2
* pin VDD
* pin VSS
.SUBCKT NND201 OUT1 IN1 IN2 VDD VSS
* device instance $1 r0 *1 5.05,9.5 N
M$1 \$6 IN1 VSS VSS N L=1.2U W=14U AS=51.8P AD=11.9P PS=35.4U PD=15.7U
* device instance $2 r0 *1 7.95,9.5 N
M$2 OUT1 IN2 \$6 VSS N L=1.2U W=14U AS=11.9P AD=57.8P PS=15.7U PD=36.8U
* device instance $3 r0 *1 5.3,34.1 P
M$3 OUT1 IN1 VDD VDD P L=1.5U W=20U AS=74P AD=39P PS=47.4U PD=23.9U
* device instance $4 r0 *1 10.7,34.1 P
M$4 VDD IN2 OUT1 VDD P L=1.5U W=20U AS=39P AD=74P PS=23.9U PD=47.4U
.ENDS NND201

* cell INVR04
* pin VDD
* pin OUT1
* pin IN1
* pin VSS
.SUBCKT INVR04 VDD OUT1 IN1 VSS
* device instance $1 r0 *1 10.45,12.95 N
M$1 OUT1 IN1 VSS VSS N L=1.2U W=22U AS=122.19P AD=40.8P PS=71.7U PD=25.6U
* device instance $2 r0 *1 5.175,35.075 P
M$2 VDD IN1 OUT1 VDD P L=1.5U W=50U AS=166.2075P AD=166.2075P PS=87.85U
+ PD=87.85U
.ENDS INVR04

* cell AOI401
* pin B
* pin D
* pin OUT1
* pin A
* pin C
* pin VDD
* pin VSS
.SUBCKT AOI401 B D OUT1 A C VDD VSS
* device instance $1 r0 *1 34.15,12.35 N
M$1 VSS \$4 \$5 VSS N L=1.2U W=9U AS=33.3P AD=19.3P PS=25.4U PD=13.4U
* device instance $2 r0 *1 39.75,13.35 N
M$2 OUT1 \$5 VSS VSS N L=1.2U W=7U AS=19.3P AD=26.25P PS=13.4U PD=21.5U
* device instance $3 r0 *1 18.45,12.35 N
M$3 \$10 C \$4 VSS N L=1.2U W=9U AS=33.3P AD=9P PS=25.4U PD=11U
* device instance $4 r0 *1 21.65,12.35 N
M$4 VSS D \$10 VSS N L=1.2U W=9U AS=9P AD=33.3P PS=11U PD=25.4U
* device instance $5 r0 *1 5.15,12.35 N
M$5 \$9 A VSS VSS N L=1.2U W=9U AS=33.3P AD=9P PS=25.4U PD=11U
* device instance $6 r0 *1 8.35,12.35 N
M$6 \$4 B \$9 VSS N L=1.2U W=9U AS=9P AD=33.3P PS=11U PD=25.4U
* device instance $7 r0 *1 32.15,33.7 P
M$7 VDD \$4 \$5 VDD P L=1.5U W=10U AS=37P AD=39.87P PS=27.4U PD=24.4U
* device instance $8 r0 *1 39.7,34.35 P
M$8 OUT1 \$5 VDD VDD P L=1.5U W=15U AS=39.87P AD=36.26P PS=24.4U PD=27U
* device instance $9 r0 *1 5.4,33.7 P
M$9 VDD A \$11 VDD P L=1.5U W=10U AS=37P AD=19.5P PS=27.4U PD=13.9U
* device instance $10 r0 *1 10.8,33.7 P
M$10 \$11 B VDD VDD P L=1.5U W=10U AS=19.5P AD=19.5P PS=13.9U PD=13.9U
* device instance $11 r0 *1 16.2,33.7 P
M$11 \$4 C \$11 VDD P L=1.5U W=10U AS=19.5P AD=19.5P PS=13.9U PD=13.9U
* device instance $12 r0 *1 21.6,33.7 P
M$12 \$11 D \$4 VDD P L=1.5U W=10U AS=19.5P AD=38.5P PS=13.9U PD=27.7U
.ENDS AOI401

* cell OR2101
* pin IN1
* pin OUT1
* pin VDD
* pin IN2
* pin VSS
.SUBCKT OR2101 IN1 OUT1 VDD IN2 VSS
* device instance $1 r0 *1 5.15,11 N
M$1 \$2 IN1 VSS VSS N L=1.2U W=7U AS=25.9P AD=13.65P PS=21.4U PD=10.9U
* device instance $2 r0 *1 10.25,11 N
M$2 VSS IN2 \$2 VSS N L=1.2U W=7U AS=13.65P AD=20.75P PS=10.9U PD=14U
* device instance $3 r0 *1 15.95,12.25 N
M$3 OUT1 \$2 VSS VSS N L=1.2U W=9.5U AS=20.75P AD=35.15P PS=14U PD=26.4U
* device instance $4 r0 *1 5.3,31.7 P
M$4 \$7 IN1 \$2 VDD P L=1.5U W=14U AS=51.8P AD=14P PS=35.4U PD=16U
* device instance $5 r0 *1 8.8,31.7 P
M$5 VDD IN2 \$7 VDD P L=1.5U W=14U AS=14P AD=43.5P PS=16U PD=21.5U
* device instance $6 r0 *1 15.8,32.7 P
M$6 OUT1 \$2 VDD VDD P L=1.5U W=16U AS=43.5P AD=59.2P PS=21.5U PD=39.4U
.ENDS OR2101

* cell XNR201
* pin
* pin IN2
* pin OUT1
* pin VDD
* pin VSS
.SUBCKT XNR201 \$2 IN2 OUT1 VDD VSS
* device instance $1 r0 *1 5.05,12.5 N
M$1 \$4 IN2 VSS VSS N L=1.2U W=5U AS=18.5P AD=9.75P PS=17.4U PD=8.9U
* device instance $2 r0 *1 10.15,12.5 N
M$2 VSS \$2 \$4 VSS N L=1.2U W=5U AS=9.75P AD=9.75P PS=8.9U PD=8.9U
* device instance $3 r0 *1 15.25,12.5 N
M$3 \$5 \$4 VSS VSS N L=1.2U W=5U AS=9.75P AD=9.75P PS=8.9U PD=8.9U
* device instance $4 r0 *1 20.35,12.5 N
M$4 \$7 IN2 \$5 VSS N L=1.2U W=5U AS=9.75P AD=6.5P PS=8.9U PD=7.6U
* device instance $5 r0 *1 24.15,12.5 N
M$5 \$7 \$2 VSS VSS N L=1.2U W=5U AS=16.05P AD=6.5P PS=12.2U PD=7.6U
* device instance $6 r0 *1 29.55,13 N
M$6 OUT1 \$5 VSS VSS N L=1.2U W=8U AS=16.05P AD=29.6P PS=12.2U PD=23.4U
* device instance $7 r0 *1 21.6,29.6 P
M$7 \$5 \$4 \$9 VDD P L=1.5U W=15U AS=14.3466666667P AD=36.25P
+ PS=17.7333333333U PD=27U
* device instance $8 r0 *1 5.2,33.7 P
M$8 \$11 IN2 \$4 VDD P L=1.5U W=15U AS=55.5P AD=15P PS=37.4U PD=17U
* device instance $9 r0 *1 8.7,33.7 P
M$9 VDD \$2 \$11 VDD P L=1.5U W=15U AS=15P AD=29.25P PS=17U PD=18.9U
* device instance $10 r0 *1 14.1,33.7 P
M$10 \$9 \$2 VDD VDD P L=1.5U W=15U AS=29.25P AD=14.3466666667P PS=18.9U
+ PD=17.7333333333U
* device instance $11 r0 *1 21.45,37.95 P
M$11 VDD IN2 \$9 VDD P L=1.5U W=15U AS=14.3466666667P AD=42.5P
+ PS=17.7333333333U PD=27U
* device instance $12 r0 *1 32.6,32 P
M$12 OUT1 \$5 VDD VDD P L=1.5U W=16U AS=59.2P AD=59.2P PS=39.4U PD=39.4U
.ENDS XNR201

* cell DFCL11
* pin C
* pin CLRB
* pin D
* pin QB
* pin Q
* pin VDD
* pin VSS
.SUBCKT DFCL11 C CLRB D QB Q VDD VSS
* device instance $1 r0 *1 3.875,13.125 N
M$1 \$4 C VSS VSS N L=1.23165829146U W=9.95U AS=27.0825P AD=22.1225P PS=18.8U
+ PD=19.7U
* device instance $2 r0 *1 10.25,13.05 N
M$2 \$14 \$4 VSS VSS N L=1.2U W=7.6U AS=27.0825P AD=28.12P PS=18.8U PD=22.6U
* device instance $3 r0 *1 23.05,13.25 N
M$3 \$6 \$4 D VSS N L=1.2U W=6.5U AS=24.05P AD=12.675P PS=20.4U PD=10.4U
* device instance $4 r0 *1 28.15,13.25 N
M$4 \$7 \$14 \$6 VSS N L=1.2U W=6.5U AS=12.675P AD=12.675P PS=10.4U PD=10.4U
* device instance $5 r0 *1 33.25,13.25 N
M$5 \$7 \$8 VSS VSS N L=1.2U W=6.5U AS=15.075P AD=12.675P PS=11.9U PD=10.4U
* device instance $6 r0 *1 38.35,12.5 N
M$6 \$15 \$6 VSS VSS N L=1.2U W=8U AS=15.075P AD=8P PS=11.9U PD=10U
* device instance $7 r0 *1 41.55,12.5 N
M$7 \$8 CLRB \$15 VSS N L=1.2U W=8U AS=8P AD=29.85P PS=10U PD=16.1U
* device instance $8 r0 *1 50.85,13.25 N
M$8 \$9 \$14 \$8 VSS N L=1.2U W=6.5U AS=29.85P AD=12.675P PS=16.1U PD=10.4U
* device instance $9 r0 *1 55.95,13.25 N
M$9 \$9 \$4 \$10 VSS N L=1.2U W=6.5U AS=13.61375P AD=12.675P PS=10.9U PD=10.4U
* device instance $10 r0 *1 61.1,13.025 N
M$10 \$16 CLRB \$10 VSS N L=1.2U W=6.95U AS=13.61375P AD=6.95P PS=10.9U PD=8.95U
* device instance $11 r0 *1 64.3,13.025 N
M$11 VSS \$11 \$16 VSS N L=1.2U W=6.95U AS=6.95P AD=18.93875P PS=8.95U PD=12.4U
* device instance $12 r0 *1 70.95,13.025 N
M$12 \$11 \$9 VSS VSS N L=1.2U W=6.95U AS=18.93875P AD=25.715P PS=12.4U PD=21.3U
* device instance $13 r0 *1 88.65,12 N
M$13 VSS \$11 QB VSS N L=1.2U W=9U AS=33.3P AD=17.55P PS=25.4U PD=12.9U
* device instance $14 r0 *1 93.75,12 N
M$14 Q QB VSS VSS N L=1.2U W=9U AS=17.55P AD=36P PS=12.9U PD=26U
* device instance $15 r0 *1 53.1,36.2 P
M$15 \$9 \$4 \$8 VDD P L=1.5U W=8U AS=22.4P AD=15.6P PS=15.9U PD=11.9U
* device instance $16 r0 *1 58.5,36.2 P
M$16 \$10 \$14 \$9 VDD P L=1.5U W=8U AS=15.6P AD=15.6P PS=11.9U PD=11.9U
* device instance $17 r0 *1 63.9,36.2 P
M$17 VDD CLRB \$10 VDD P L=1.5U W=8U AS=15.6P AD=15.6P PS=11.9U PD=11.9U
* device instance $18 r0 *1 69.3,36.2 P
M$18 \$10 \$11 VDD VDD P L=1.5U W=8U AS=15.6P AD=29.005P PS=11.9U PD=23.4U
* device instance $19 r0 *1 42.3,38.2 P
M$19 VDD \$6 \$8 VDD P L=1.5U W=12U AS=44.4P AD=23.4P PS=31.4U PD=15.9U
* device instance $20 r0 *1 47.7,38.2 P
M$20 \$8 CLRB VDD VDD P L=1.5U W=12U AS=23.4P AD=22.4P PS=15.9U PD=15.9U
* device instance $21 r0 *1 12.55,34.675 P
M$21 \$14 \$4 VDD VDD P L=1.5U W=16.05U AS=53.095P AD=40.145P PS=30.2U PD=29.1U
* device instance $22 r0 *1 4.05,35.2 P
M$22 VDD C \$4 VDD P L=1.5U W=15.9U AS=43.07P AD=53.095P PS=31.2U PD=30.2U
* device instance $23 r0 *1 21.1,36.2 P
M$23 \$6 \$14 D VDD P L=1.5U W=8U AS=28.04P AD=15.6P PS=23.4U PD=11.9U
* device instance $24 r0 *1 26.5,36.2 P
M$24 \$7 \$4 \$6 VDD P L=1.5U W=8U AS=15.6P AD=16.4925P PS=11.9U PD=12.6U
* device instance $25 r0 *1 31.9,36.9 P
M$25 VDD \$8 \$7 VDD P L=1.5U W=8U AS=16.4925P AD=29.6P PS=12.6U PD=23.4U
* device instance $26 r0 *1 77.85,34.6 P
M$26 VDD \$9 \$11 VDD P L=1.5U W=15.5U AS=37.65875P AD=76.59P PS=27.444U
+ PD=48.8U
* device instance $27 r0 *1 90.1,34.1 P
M$27 VDD \$11 QB VDD P L=1.5U W=20U AS=74P AD=39P PS=47.4U PD=23.9U
* device instance $28 r0 *1 95.5,34.1 P
M$28 Q QB VDD VDD P L=1.5U W=20U AS=39P AD=74P PS=23.9U PD=47.4U
.ENDS DFCL11

* cell AND201
* pin VDD
* pin OUT1
* pin IN2
* pin IN1
* pin VSS
.SUBCKT AND201 VDD OUT1 IN2 IN1 VSS
* device instance $1 r0 *1 5.15,12.3 N
M$1 \$7 IN1 \$4 VSS N L=1.2U W=5.5U AS=20.35P AD=5.5P PS=18.4U PD=7.5U
* device instance $2 r0 *1 8.35,12.3 N
M$2 \$7 IN2 VSS VSS N L=1.2U W=5.5U AS=29.7925P AD=5.5P PS=18.7U PD=7.5U
* device instance $3 r0 *1 15.6,12.425 N
M$3 OUT1 \$4 VSS VSS N L=1.2U W=8.95U AS=29.7925P AD=14.985P PS=18.7U PD=15.5U
* device instance $4 r0 *1 5.3,34.6 P
M$4 \$4 IN1 VDD VDD P L=1.5U W=7U AS=25.9P AD=13.65P PS=21.4U PD=10.9U
* device instance $5 r0 *1 10.7,34.6 P
M$5 \$4 IN2 VDD VDD P L=1.5U W=7U AS=42.6325P AD=13.65P PS=25.75U PD=10.9U
* device instance $6 r0 *1 18.55,32.25 P
M$6 OUT1 \$4 VDD VDD P L=1.5U W=16U AS=42.6325P AD=43.86P PS=25.75U PD=29U
.ENDS AND201

* cell DFFL11
* pin C
* pin D
* pin QB
* pin Q
* pin VDD
* pin VSS
.SUBCKT DFFL11 C D QB Q VDD VSS
* device instance $1 r0 *1 72.15,11.9 N
M$1 VSS \$4 QB VSS N L=1.2U W=10U AS=40P AD=21P PS=28U PD=14.2U
* device instance $2 r0 *1 77.55,11.9 N
M$2 Q QB VSS VSS N L=1.2U W=10U AS=21P AD=37P PS=14.2U PD=27.4U
* device instance $3 r0 *1 5.15,11.9 N
M$3 VSS C \$5 VSS N L=1.2U W=10U AS=37P AD=19.5P PS=27.4U PD=13.9U
* device instance $4 r0 *1 10.25,11.9 N
M$4 \$12 \$5 VSS VSS N L=1.2U W=10U AS=19.5P AD=37P PS=13.9U PD=27.4U
* device instance $5 r0 *1 21.75,13.25 N
M$5 \$7 \$5 D VSS N L=1.2U W=6.5U AS=26P AD=13.65P PS=21U PD=10.7U
* device instance $6 r0 *1 27.15,13.25 N
M$6 \$7 \$12 \$14 VSS N L=1.2U W=6.5U AS=13.4375P AD=13.65P PS=10.9U PD=10.7U
* device instance $7 r0 *1 32.25,13 N
M$7 VSS \$3 \$14 VSS N L=1.2U W=7U AS=13.4375P AD=19.95P PS=10.9U PD=12.7U
* device instance $8 r0 *1 39.15,13 N
M$8 \$3 \$7 VSS VSS N L=1.2U W=7U AS=19.95P AD=13.4125P PS=12.7U PD=10.9U
* device instance $9 r0 *1 44.25,13.25 N
M$9 \$8 \$12 \$3 VSS N L=1.2U W=6.5U AS=13.4125P AD=13.325P PS=10.9U PD=10.6U
* device instance $10 r0 *1 49.55,13.25 N
M$10 \$8 \$5 \$9 VSS N L=1.2U W=6.5U AS=14.7625P AD=13.325P PS=11.3U PD=10.6U
* device instance $11 r0 *1 55.05,13 N
M$11 VSS \$4 \$9 VSS N L=1.2U W=7U AS=14.7625P AD=13.65P PS=11.3U PD=10.9U
* device instance $12 r0 *1 60.15,13 N
M$12 \$4 \$8 VSS VSS N L=1.2U W=7U AS=13.65P AD=30.1P PS=10.9U PD=22.6U
* device instance $13 r0 *1 72,34 P
M$13 VDD \$4 QB VDD P L=1.5U W=20U AS=74P AD=39P PS=47.4U PD=23.9U
* device instance $14 r0 *1 77.4,34 P
M$14 Q QB VDD VDD P L=1.5U W=20U AS=39P AD=74P PS=23.9U PD=47.4U
* device instance $15 r0 *1 21.6,36.2 P
M$15 \$7 \$12 D VDD P L=1.5U W=8U AS=29.6P AD=15.6P PS=23.4U PD=11.9U
* device instance $16 r0 *1 27,36.2 P
M$16 \$14 \$5 \$7 VDD P L=1.5U W=8U AS=15.6P AD=20.325P PS=11.9U PD=15U
* device instance $17 r0 *1 44.4,36.2 P
M$17 \$8 \$5 \$3 VDD P L=1.5U W=8U AS=20.5P AD=15.6P PS=15U PD=11.9U
* device instance $18 r0 *1 49.8,36.2 P
M$18 \$8 \$12 \$9 VDD P L=1.5U W=8U AS=28.35P AD=15.6P PS=19.4U PD=11.9U
* device instance $19 r0 *1 55.2,36.25 P
M$19 VDD \$4 \$9 VDD P L=1.5U W=15.5U AS=28.35P AD=30.225P PS=19.4U PD=19.4U
* device instance $20 r0 *1 60.6,36.25 P
M$20 \$4 \$8 VDD VDD P L=1.5U W=15.5U AS=30.225P AD=57.35P PS=19.4U PD=38.4U
* device instance $21 r0 *1 32,38.55 P
M$21 VDD \$3 \$14 VDD P L=1.5U W=13.3U AS=20.325P AD=42.9P PS=15U PD=26.6U
* device instance $22 r0 *1 39.4,38.2 P
M$22 \$3 \$7 VDD VDD P L=1.5U W=14U AS=42.9P AD=20.5P PS=26.6U PD=15U
* device instance $23 r0 *1 5.3,36 P
M$23 VDD C \$5 VDD P L=1.5U W=16U AS=59.2P AD=31.2P PS=39.4U PD=19.9U
* device instance $24 r0 *1 10.7,36 P
M$24 \$12 \$5 VDD VDD P L=1.5U W=16U AS=31.2P AD=59.2P PS=19.9U PD=39.4U
.ENDS DFFL11

* cell INVR01
* pin OUT1
* pin VDD
* pin IN1
* pin VSS
.SUBCKT INVR01 OUT1 VDD IN1 VSS
* device instance $1 r0 *1 6.45,13.05 N
M$1 OUT1 IN1 VSS VSS N L=1.2U W=7U AS=26.25P AD=27.3P PS=21.5U PD=21.8U
* device instance $2 r0 *1 6.5,33.5 P
M$2 OUT1 IN1 VDD VDD P L=1.5U W=14U AS=54.6P AD=51.8P PS=35.8U PD=35.4U
.ENDS INVR01

* cell INVR05
* pin OUT1
* pin VDD
* pin IN1
* pin VSS
.SUBCKT INVR05 OUT1 VDD IN1 VSS
* device instance $1 r0 *1 13.45,12.95 N
M$1 OUT1 IN1 VSS VSS N L=1.2U W=28U AS=143.22P AD=81.6P PS=83.4U PD=37.6U
* device instance $2 r0 *1 20.575,33.375 P
M$2 OUT1 IN1 VDD VDD P L=1.5U W=62U AS=283.365P AD=125.1375P PS=129.4U PD=79.9U
.ENDS INVR05

* cell INVR02
* pin VDD
* pin IN1
* pin OUT1
* pin VSS
.SUBCKT INVR02 VDD IN1 OUT1 VSS
* device instance $1 r0 *1 10.275,13.025 N
M$1 OUT1 IN1 VSS VSS N L=1.2U W=13U AS=71.605P AD=30.7275P PS=44.2U PD=23.6U
* device instance $2 r0 *1 8.45,36.1 P
M$2 OUT1 IN1 VDD VDD P L=1.5U W=28U AS=148.2025P AD=42P PS=85U PD=29U
.ENDS INVR02

* cell INVR03
* pin VDD
* pin IN1
* pin OUT1
* pin VSS
.SUBCKT INVR03 VDD IN1 OUT1 VSS
* device instance $1 r0 *1 8.1,13.3 N
M$1 OUT1 IN1 VSS VSS N L=1.2U W=17U AS=114.64P AD=21.2P PS=63.3U PD=18.6U
* device instance $2 r0 *1 8.25,34.3 P
M$2 OUT1 IN1 VDD VDD P L=1.5U W=39U AS=185.625P AD=64P PS=106.5U PD=40U
.ENDS INVR03

* cell INVR06
* pin VDD
* pin OUT1
* pin IN1
* pin VSS
.SUBCKT INVR06 VDD OUT1 IN1 VSS
* device instance $1 r0 *1 14.75,12.65 N
M$1 OUT1 IN1 VSS VSS N L=1.2U W=33U AS=160.13P AD=86P PS=93.3U PD=53.8U
* device instance $2 r0 *1 10.5,33.425 P
M$2 OUT1 IN1 VDD VDD P L=1.5U W=73U AS=288.41P AD=118P PS=157.9U PD=75U
.ENDS INVR06
